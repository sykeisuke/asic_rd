* analog_top (v7, mixed_signal/Analog_top) -- the analog macro of the 8-bit
* true bottom-plate single-slope ADC: four sampling/conversion cells on one
* shared ramp (ramp_simple: 73 unit MIMs + reset, fed by the I/C current
* source ic_source; ADR 0025 / 0026), bias_gen_s, vrlo_ref (7/55 AVDD), one
* midref_div and ONE midref_buf whose output vref is both the S2 level and
* every comparator's inp (midrail_ref, ADR 0021). Every analog block is inside,
* and the sampling sequencer sample_seq (v7, ADR 0027): the twelve switch
* controls are made inside from the count clock and acq.
*
* GENERATED from analog_top.sch by schematic.sh (xschem, hierarchical: every
* block down to transistors, as drawn). DO NOT HAND-EDIT. Change the drawings
* (analog_top_sch.py, the blocks' own .sch) and rewrite this file with
*   ./scripts/sim.sh analog-top PHASES=schematic REGEN=1
* Without REGEN the schematic phase FAILs while this file differs from what
* the drawings netlist to.
*
* Subcircuits: analog_top, atop_cell, comparator_d (comparator + its pbias
* diode, flat), ramp_simple, ic_source, sample_seq, seq_dly, seq_cell,
* bias_gen_s (bias_gen - XOB/ivbl + XOL -> ivrlo), vrlo_ref, midref_div,
* midref_buf, latch, sw_s0, sw_s1, sw_s2. ic_source's phase generator and
* sample_seq are standard cells (not defined here).
* comparator_d and sw_s0/1/2 carry
* drawn S/D junction geometry (the PDK MOS symbols' ad/as/pd/ps/nrd/nrs; the
* switches' from their deck), bias_gen_s its deck's. latch is one
* standard cell, gf180mcu_as_sc_mcu7t3v3__dfxtn_2 (not defined here).
* Plates: bot = MIM terminal 1, S2 to vref, comparator inn (floats during the
* conversion); top = MIM terminal 2, S0 from vfe, S1 from vramp.
* No plate leak resistor: a bench that needs a DC path on the floating plate
* adds it itself (tb_analog_top.spice: .options rshunt=1e15).
* No model or parameter card and no parameter reference: the including deck
* carries the PDK models (typical / res_typical / mimcap_typical) and the
* standard-cell library gf180mcu_as_sc_mcu7t3v3.spice (make pdk-libs;
* /foss/pdk_libs). Against v6 (data/v6_ref/analog_top.spice): check_equiv.py.
*
** sch_path: /foss/designs/mixed_signal/Analog_top/analog_top.sch
.subckt analog_top vin ramp_rst cnt_clk acq q0 q1 q2 q3 avdd avss dvdd dvss
*.PININFO vin:I ramp_rst:I cnt_clk:I acq:I q0:O q1:O q2:O q3:O avdd:B avss:B dvdd:B dvss:B
VMBG avdd avdd_bg 0
VMREF avdd avdd_ref 0
VMVRLO avdd avdd_vrlo 0
VMRAMP avdd avdd_ramp 0
VMC0 avdd avdd_c0 0
VMC1 avdd avdd_c1 0
VMC2 avdd avdd_c2 0
VMC3 avdd avdd_c3 0
XBG avdd_bg avss pbias0 pbias1 pbias2 pbias3 pbias_r ivref ivrlo bias_gen_s
XDIV vmid avdd_ref avss midref_div
XVREF vref vmid ivref avdd_ref avss midref_buf
XVRLO vrlo ivrlo avdd_vrlo avss vrlo_ref
XIC vramp pbias_r cnt_clk avdd_ramp dvdd avss dvss ic_source
XRAMP vramp ramp_rst vrlo avss ramp_simple
XC0 vin vramp s0_0 s1_0 s2_0 vref vref pbias0 q0 cnt_clk avdd_c0 avss dvdd dvss atop_cell
XC1 vin vramp s0_1 s1_1 s2_1 vref vref pbias1 q1 cnt_clk avdd_c1 avss dvdd dvss atop_cell
XC2 vin vramp s0_2 s1_2 s2_2 vref vref pbias2 q2 cnt_clk avdd_c2 avss dvdd dvss atop_cell
XC3 vin vramp s0_3 s1_3 s2_3 vref vref pbias3 q3 cnt_clk avdd_c3 avss dvdd dvss atop_cell
XSEQ acq cnt_clk s2_0 s2_1 s2_2 s2_3 s0_0 s0_1 s0_2 s0_3 s1_0 s1_1 s1_2 s1_3 dvdd dvss sample_seq
.ends

* expanding   symbol:  bias_gen_s.sym # of pins=9
** sym_path: /foss/designs/mixed_signal/Analog_top/bias_gen_s.sym
** sch_path: /foss/designs/mixed_signal/Analog_top/bias_gen_s.sch
.subckt bias_gen_s vdd vss icmp0 icmp1 icmp2 icmp3 iramp ivref ivrlo
*.PININFO vdd:B vss:B icmp0:B icmp1:B icmp2:B icmp3:B iramp:B ivref:B ivrlo:B
XMN1 nb nb vss vss nfet_03v3 L=0.9u W=40u nf=10 m=1 ad=3.6p pd=41.8u as=4.32p ps=50.16u nrd=0.0045 nrs=0.0045
XMN2 pb nb ns vss nfet_03v3 L=0.9u W=80u nf=20 m=4 ad=7.2p pd=83.6u as=7.92p ps=91.96u nrd=0.00225 nrs=0.00225
XMP1 nb pb vdd vdd pfet_03v3 L=0.9u W=56u nf=14 m=1 ad=5.04p pd=58.52u as=5.76p ps=66.88u nrd=0.003214 nrs=0.003214
XMP2 pb pb vdd vdd pfet_03v3 L=0.9u W=56u nf=14 m=1 ad=5.04p pd=58.52u as=5.76p ps=66.88u nrd=0.003214 nrs=0.003214
XR1 ns r1 vss ppolyf_u r_width=1u r_length=10.7324u
XR2 r1 r2 vss ppolyf_u r_width=1u r_length=10.7324u
XR3 r2 r3 vss ppolyf_u r_width=1u r_length=10.7324u
XR4 r3 r4 vss ppolyf_u r_width=1u r_length=10.7324u
XR5 r4 vss vss ppolyf_u r_width=1u r_length=10.7324u
XOC0 icmp0 nb vss vss nfet_03v3 L=0.9u W=32u nf=8 m=1 ad=2.88p pd=33.44u as=3.6p ps=41.8u nrd=0.005625 nrs=0.005625
XOC1 icmp1 nb vss vss nfet_03v3 L=0.9u W=32u nf=8 m=1 ad=2.88p pd=33.44u as=3.6p ps=41.8u nrd=0.005625 nrs=0.005625
XOC2 icmp2 nb vss vss nfet_03v3 L=0.9u W=32u nf=8 m=1 ad=2.88p pd=33.44u as=3.6p ps=41.8u nrd=0.005625 nrs=0.005625
XOC3 icmp3 nb vss vss nfet_03v3 L=0.9u W=32u nf=8 m=1 ad=2.88p pd=33.44u as=3.6p ps=41.8u nrd=0.005625 nrs=0.005625
XOR iramp nb vss vss nfet_03v3 L=0.9u W=32u nf=8 m=1 ad=2.88p pd=33.44u as=3.6p ps=41.8u nrd=0.005625 nrs=0.005625
XOV ivref pb vdd vdd pfet_03v3 L=0.9u W=88u nf=22 m=2 ad=7.92p pd=91.96u as=8.64p ps=100.3u nrd=0.002045 nrs=0.002045
XSB1 sb1 sb1 vdd vdd pfet_03v3 L=0.9u W=4u nf=1 m=1 ad=0.72p pd=8.36u as=0.72p ps=8.36u nrd=0.045 nrs=0.045
XSB2 sb2 sb2 sb1 vdd pfet_03v3 L=0.9u W=4u nf=1 m=1 ad=0.72p pd=8.36u as=0.72p ps=8.36u nrd=0.045 nrs=0.045
XSB3 sb3 sb3 sb2 vdd pfet_03v3 L=0.9u W=4u nf=1 m=1 ad=0.72p pd=8.36u as=0.72p ps=8.36u nrd=0.045 nrs=0.045
XSB4 su su sb3 vdd pfet_03v3 L=0.9u W=4u nf=1 m=1 ad=0.72p pd=8.36u as=0.72p ps=8.36u nrd=0.045 nrs=0.045
XSU4 su nb vss vss nfet_03v3 L=0.9u W=4u nf=1 m=1 ad=0.72p pd=8.36u as=0.72p ps=8.36u nrd=0.045 nrs=0.045
XSU5 pb su vss vss nfet_03v3 L=0.9u W=4u nf=1 m=1 ad=0.72p pd=8.36u as=0.72p ps=8.36u nrd=0.045 nrs=0.045
XCP vdd pb cap_mim_2f0_m4m5_noshield c_width=22.3607u c_length=22.3607u
XCN nb vss cap_mim_2f0_m4m5_noshield c_width=22.3607u c_length=22.3607u
XOL ivrlo pb vdd vdd pfet_03v3 L=0.9u W=24u nf=6 m=1 ad=2.16p pd=25.08u as=2.88p ps=33.44u nrd=0.0075 nrs=0.0075
.ends

* expanding   symbol:  midref_div.sym # of pins=3
** sym_path: /foss/designs/mixed_signal/Analog_top/midref_div.sym
** sch_path: /foss/designs/mixed_signal/midrail_ref/midref_div.sch
.subckt midref_div vin vdd vss
*.PININFO vdd:B vss:B vin:O
XRT vdd vin vss ppolyf_u_3k r_width=1u r_length=64.98u
XRB vin vss vss ppolyf_u_3k r_width=1u r_length=64.98u
XCT vin vss cap_mim_2f0_m4m5_noshield c_width=4.423u c_length=4.423u
.ends

* expanding   symbol:  midref_buf.sym # of pins=5
** sym_path: /foss/designs/mixed_signal/Analog_top/midref_buf.sym
** sch_path: /foss/designs/mixed_signal/midrail_ref/midref_buf.sch
.subckt midref_buf out vin ib vdd vss
*.PININFO vdd:B vss:B ib:I vin:I out:O
XMBN ib ib vss vss nfet_03v3 L=0.34u W=0.5u nf=1
XMBN2 pb ib vss vss nfet_03v3 L=0.34u W=0.5u nf=1
XMBP pb pb vdd vdd pfet_03v3 L=0.34u W=2u nf=1
XMIT a pb vdd vdd pfet_03v3 L=0.34u W=2u nf=1
XMIB b ib vss vss nfet_03v3 L=0.34u W=0.5u nf=1
XM3 p b vdd vdd pfet_03v3 L=0.36u W=2u nf=1
XM1 b vin p vdd pfet_03v3 L=0.34u W=40u nf=20
XM2 out out p vdd pfet_03v3 L=0.34u W=40u nf=20
XM6 n a vss vss nfet_03v3 L=0.36u W=0.5u nf=1
XM4 a vin n vss nfet_03v3 L=0.34u W=13u nf=26
XM5 out out n vss nfet_03v3 L=0.34u W=13u nf=26
XCD out vss cap_mim_2f0_m4m5_noshield c_width=11.7u c_length=11.7u
.ends

* expanding   symbol:  vrlo_ref.sym # of pins=4
** sym_path: /foss/designs/mixed_signal/Analog_top/vrlo_ref.sym
** sch_path: /foss/designs/mixed_signal/vrlo_ref/vrlo_ref.sch
.subckt vrlo_ref vrlo ib avdd avss
*.PININFO avdd:B avss:B ib:I vrlo:O
XR1 avdd r1 avss ppolyf_u_3k r_width=1u r_length=20u
XR2 r1 r2 avss ppolyf_u_3k r_width=1u r_length=20u
XR3 r2 r3 avss ppolyf_u_3k r_width=1u r_length=20u
XR4 r3 r4 avss ppolyf_u_3k r_width=1u r_length=20u
XR5 r4 r5 avss ppolyf_u_3k r_width=1u r_length=20u
XR6 r5 r6 avss ppolyf_u_3k r_width=1u r_length=20u
XR7 r6 r7 avss ppolyf_u_3k r_width=1u r_length=20u
XR8 r7 r8 avss ppolyf_u_3k r_width=1u r_length=20u
XR9 r8 r9 avss ppolyf_u_3k r_width=1u r_length=20u
XR10 r9 r10 avss ppolyf_u_3k r_width=1u r_length=20u
XR11 r10 r11 avss ppolyf_u_3k r_width=1u r_length=20u
XR12 r11 r12 avss ppolyf_u_3k r_width=1u r_length=20u
XR13 r12 r13 avss ppolyf_u_3k r_width=1u r_length=20u
XR14 r13 r14 avss ppolyf_u_3k r_width=1u r_length=20u
XR15 r14 r15 avss ppolyf_u_3k r_width=1u r_length=20u
XR16 r15 r16 avss ppolyf_u_3k r_width=1u r_length=20u
XR17 r16 r17 avss ppolyf_u_3k r_width=1u r_length=20u
XR18 r17 r18 avss ppolyf_u_3k r_width=1u r_length=20u
XR19 r18 r19 avss ppolyf_u_3k r_width=1u r_length=20u
XR20 r19 r20 avss ppolyf_u_3k r_width=1u r_length=20u
XR21 r20 r21 avss ppolyf_u_3k r_width=1u r_length=20u
XR22 r21 r22 avss ppolyf_u_3k r_width=1u r_length=20u
XR23 r22 r23 avss ppolyf_u_3k r_width=1u r_length=20u
XR24 r23 r24 avss ppolyf_u_3k r_width=1u r_length=20u
XR25 r24 r25 avss ppolyf_u_3k r_width=1u r_length=20u
XR26 r25 r26 avss ppolyf_u_3k r_width=1u r_length=20u
XR27 r26 r27 avss ppolyf_u_3k r_width=1u r_length=20u
XR28 r27 r28 avss ppolyf_u_3k r_width=1u r_length=20u
XR29 r28 r29 avss ppolyf_u_3k r_width=1u r_length=20u
XR30 r29 r30 avss ppolyf_u_3k r_width=1u r_length=20u
XR31 r30 r31 avss ppolyf_u_3k r_width=1u r_length=20u
XR32 r31 r32 avss ppolyf_u_3k r_width=1u r_length=20u
XR33 r32 r33 avss ppolyf_u_3k r_width=1u r_length=20u
XR34 r33 r34 avss ppolyf_u_3k r_width=1u r_length=20u
XR35 r34 r35 avss ppolyf_u_3k r_width=1u r_length=20u
XR36 r35 r36 avss ppolyf_u_3k r_width=1u r_length=20u
XR37 r36 r37 avss ppolyf_u_3k r_width=1u r_length=20u
XR38 r37 r38 avss ppolyf_u_3k r_width=1u r_length=20u
XR39 r38 r39 avss ppolyf_u_3k r_width=1u r_length=20u
XR40 r39 r40 avss ppolyf_u_3k r_width=1u r_length=20u
XR41 r40 r41 avss ppolyf_u_3k r_width=1u r_length=20u
XR42 r41 r42 avss ppolyf_u_3k r_width=1u r_length=20u
XR43 r42 r43 avss ppolyf_u_3k r_width=1u r_length=20u
XR44 r43 r44 avss ppolyf_u_3k r_width=1u r_length=20u
XR45 r44 r45 avss ppolyf_u_3k r_width=1u r_length=20u
XR46 r45 r46 avss ppolyf_u_3k r_width=1u r_length=20u
XR47 r46 r47 avss ppolyf_u_3k r_width=1u r_length=20u
XR48 r47 tap avss ppolyf_u_3k r_width=1u r_length=20u
XR49 tap r49 avss ppolyf_u_3k r_width=1u r_length=20u
XR50 r49 r50 avss ppolyf_u_3k r_width=1u r_length=20u
XR51 r50 r51 avss ppolyf_u_3k r_width=1u r_length=20u
XR52 r51 r52 avss ppolyf_u_3k r_width=1u r_length=20u
XR53 r52 r53 avss ppolyf_u_3k r_width=1u r_length=20u
XR54 r53 r54 avss ppolyf_u_3k r_width=1u r_length=20u
XR55 r54 avss avss ppolyf_u_3k r_width=1u r_length=20u
XCT tap avss cap_mim_2f0_m4m5_noshield c_width=22.4u c_length=22.4u
XMBN ib ib avss avss nfet_03v3 L=1u W=1u nf=1
XMBN2 pb ib avss avss nfet_03v3 L=1u W=1u nf=1
XMBP pb pb avdd avdd pfet_03v3 L=1u W=2u nf=1
XMT ts pb avdd avdd pfet_03v3 L=1u W=4u nf=2
XMK vrlo pb avdd avdd pfet_03v3 L=1u W=6u nf=3
XM1 d1 vrlo ts avdd pfet_03v3 L=0.5u W=14u nf=7
XM2 g tap ts avdd pfet_03v3 L=0.5u W=14u nf=7
XM3 d1 d1 avss avss nfet_03v3 L=1u W=6u nf=6
XM4 g d1 avss avss nfet_03v3 L=1u W=4u nf=4
XM5 g g avss avss nfet_03v3 L=1u W=2u nf=2
XMS vrlo g avss avss nfet_03v3 L=1u W=18u nf=18
XCD vrlo avss cap_mim_2f0_m4m5_noshield c_width=41.5u c_length=41.5u
.ends

* expanding   symbol:  ic_source.sym # of pins=7
** sym_path: /foss/designs/mixed_signal/ic_source/ic_source.sym
** sch_path: /foss/designs/mixed_signal/ic_source/ic_source.sch
.subckt ic_source iout ibias clk avdd dvdd avss dvss
*.PININFO avdd:B avss:B ibias:I iout:O dvdd:B dvss:B clk:I
XPB ibias ibias avdd avdd pfet_03v3 L=1.000u W=20.000u nf=10
XPNB nb ibias avdd avdd pfet_03v3 L=1.000u W=2.000u nf=1
XNB nb nb avss avss nfet_03v3 L=1.000u W=84.000u nf=42
XPNC vcasn ibias avdd avdd pfet_03v3 L=1.000u W=2.000u nf=1
XND1 vcasn vcasn ncm avss nfet_03v3 L=0.500u W=1.000u nf=1
XND2 ncm ncm avss avss nfet_03v3 L=0.500u W=4.000u nf=1
XPD1 pcm pcm avdd avdd pfet_03v3 L=0.500u W=8.000u nf=4
XPD2 vcasp vcasp pcm avdd pfet_03v3 L=0.500u W=2.000u nf=1
XNCS vcasp nb avss avss nfet_03v3 L=1.000u W=56.000u nf=28
XPL1 sl1 dl avdd avdd pfet_03v3 L=1.000u W=8.000u nf=4
XPLC1 dl vcasp sl1 avdd pfet_03v3 L=0.500u W=2.000u nf=1
XNC1 dl vcasn fh1 avss nfet_03v3 L=0.500u W=1.000u nf=1
XN1 fh1 nb avss avss nfet_03v3 L=1.000u W=56.000u nf=28
XPL2 sl2 dl avdd avdd pfet_03v3 L=1.000u W=8.000u nf=4
XPLC2 vg vcasp sl2 avdd pfet_03v3 L=0.500u W=2.000u nf=1
XNC2 vg vcasn fh2 avss nfet_03v3 L=0.500u W=1.000u nf=1
XN2 fh2 nb avss avss nfet_03v3 L=1.000u W=56.000u nf=28
XPT ts ibias avdd avdd pfet_03v3 L=1.000u W=2.000u nf=1
XIA fh1 a ts avdd pfet_03v3 L=1.000u W=56.000u nf=28
XIR fh2 vref ts avdd pfet_03v3 L=1.000u W=56.000u nf=28
XCG vg avss cap_mim_2f0_m4m5_noshield c_width=5.000u c_length=5.000u m=79
XSU1 su su avdd avdd pfet_03v3 L=0.360u W=0.220u nf=1
XSU2 vg vg su avdd pfet_03v3 L=0.360u W=0.220u nf=1
XRS1[7] s1r[6] avdd avss ppolyf_u_3k r_width=1u r_length=20u
XRS1[6] s1r[5] s1r[6] avss ppolyf_u_3k r_width=1u r_length=20u
XRS1[5] s1r[4] s1r[5] avss ppolyf_u_3k r_width=1u r_length=20u
XRS1[4] s1r[3] s1r[4] avss ppolyf_u_3k r_width=1u r_length=20u
XRS1[3] s1r[2] s1r[3] avss ppolyf_u_3k r_width=1u r_length=20u
XRS1[2] s1r[1] s1r[2] avss ppolyf_u_3k r_width=1u r_length=20u
XRS1[1] s1r[0] s1r[1] avss ppolyf_u_3k r_width=1u r_length=20u
XRS1[0] s1 s1r[0] avss ppolyf_u_3k r_width=1u r_length=20u
XM1 d1 vg s1 avdd pfet_03v3 L=1.000u W=32.000u nf=16
XM1C a vcasp d1 avdd pfet_03v3 L=0.500u W=8.000u nf=4
XRS2[7] s2r[6] avdd avss ppolyf_u_3k r_width=1u r_length=20u
XRS2[6] s2r[5] s2r[6] avss ppolyf_u_3k r_width=1u r_length=20u
XRS2[5] s2r[4] s2r[5] avss ppolyf_u_3k r_width=1u r_length=20u
XRS2[4] s2r[3] s2r[4] avss ppolyf_u_3k r_width=1u r_length=20u
XRS2[3] s2r[2] s2r[3] avss ppolyf_u_3k r_width=1u r_length=20u
XRS2[2] s2r[1] s2r[2] avss ppolyf_u_3k r_width=1u r_length=20u
XRS2[1] s2r[0] s2r[1] avss ppolyf_u_3k r_width=1u r_length=20u
XRS2[0] s2 s2r[0] avss ppolyf_u_3k r_width=1u r_length=20u
XMO d2 vg s2 avdd pfet_03v3 L=1.000u W=32.000u nf=16
XMOC iout vcasp d2 avdd pfet_03v3 L=0.500u W=8.000u nf=4
XCF a avss cap_mim_2f0_m4m5_noshield c_width=5.000u c_length=5.000u m=4
XSA a phi1 ct avss nfet_03v3 L=0.280u W=0.300u nf=1
XCU ct avss cap_mim_2f0_m4m5_noshield c_width=5.000u c_length=5.000u
XSG ct phi2 avss avss nfet_03v3 L=0.280u W=0.300u nf=1
XRU[27] ru[26] avdd avss ppolyf_u_3k r_width=1u r_length=20u
XRU[26] ru[25] ru[26] avss ppolyf_u_3k r_width=1u r_length=20u
XRU[25] ru[24] ru[25] avss ppolyf_u_3k r_width=1u r_length=20u
XRU[24] ru[23] ru[24] avss ppolyf_u_3k r_width=1u r_length=20u
XRU[23] ru[22] ru[23] avss ppolyf_u_3k r_width=1u r_length=20u
XRU[22] ru[21] ru[22] avss ppolyf_u_3k r_width=1u r_length=20u
XRU[21] ru[20] ru[21] avss ppolyf_u_3k r_width=1u r_length=20u
XRU[20] ru[19] ru[20] avss ppolyf_u_3k r_width=1u r_length=20u
XRU[19] ru[18] ru[19] avss ppolyf_u_3k r_width=1u r_length=20u
XRU[18] ru[17] ru[18] avss ppolyf_u_3k r_width=1u r_length=20u
XRU[17] ru[16] ru[17] avss ppolyf_u_3k r_width=1u r_length=20u
XRU[16] ru[15] ru[16] avss ppolyf_u_3k r_width=1u r_length=20u
XRU[15] ru[14] ru[15] avss ppolyf_u_3k r_width=1u r_length=20u
XRU[14] ru[13] ru[14] avss ppolyf_u_3k r_width=1u r_length=20u
XRU[13] ru[12] ru[13] avss ppolyf_u_3k r_width=1u r_length=20u
XRU[12] ru[11] ru[12] avss ppolyf_u_3k r_width=1u r_length=20u
XRU[11] ru[10] ru[11] avss ppolyf_u_3k r_width=1u r_length=20u
XRU[10] ru[9] ru[10] avss ppolyf_u_3k r_width=1u r_length=20u
XRU[9] ru[8] ru[9] avss ppolyf_u_3k r_width=1u r_length=20u
XRU[8] ru[7] ru[8] avss ppolyf_u_3k r_width=1u r_length=20u
XRU[7] ru[6] ru[7] avss ppolyf_u_3k r_width=1u r_length=20u
XRU[6] ru[5] ru[6] avss ppolyf_u_3k r_width=1u r_length=20u
XRU[5] ru[4] ru[5] avss ppolyf_u_3k r_width=1u r_length=20u
XRU[4] ru[3] ru[4] avss ppolyf_u_3k r_width=1u r_length=20u
XRU[3] ru[2] ru[3] avss ppolyf_u_3k r_width=1u r_length=20u
XRU[2] ru[1] ru[2] avss ppolyf_u_3k r_width=1u r_length=20u
XRU[1] ru[0] ru[1] avss ppolyf_u_3k r_width=1u r_length=20u
XRU[0] vref ru[0] avss ppolyf_u_3k r_width=1u r_length=20u
XRL[4] rl[3] vref avss ppolyf_u_3k r_width=1u r_length=20u
XRL[3] rl[2] rl[3] avss ppolyf_u_3k r_width=1u r_length=20u
XRL[2] rl[1] rl[2] avss ppolyf_u_3k r_width=1u r_length=20u
XRL[1] rl[0] rl[1] avss ppolyf_u_3k r_width=1u r_length=20u
XRL[0] avss rl[0] avss ppolyf_u_3k r_width=1u r_length=20u
XCT vref avss cap_mim_2f0_m4m5_noshield c_width=5.000u c_length=5.000u m=8
XI0 dvdd dvdd dvss dvss clkb clk gf180mcu_as_sc_mcu7t3v3__inv_2
XNR1 dvdd dvdd dvss dvss p1 phi2 clkb gf180mcu_as_sc_mcu7t3v3__nor2_2
XI1 dvdd dvdd dvss dvss p1b p1 gf180mcu_as_sc_mcu7t3v3__inv_2
XI2 dvdd dvdd dvss dvss phi1 p1b gf180mcu_as_sc_mcu7t3v3__inv_2
XNR2 dvdd dvdd dvss dvss p2 phi1 clk gf180mcu_as_sc_mcu7t3v3__nor2_2
XI3 dvdd dvdd dvss dvss p2b p2 gf180mcu_as_sc_mcu7t3v3__inv_2
XI4 dvdd dvdd dvss dvss phi2 p2b gf180mcu_as_sc_mcu7t3v3__inv_2
.ends

* expanding   symbol:  ramp_simple.sym # of pins=4
** sym_path: /foss/designs/mixed_signal/ramp_simple/ramp_simple.sym
** sch_path: /foss/designs/mixed_signal/ramp_simple/ramp_simple.sch
.subckt ramp_simple vramp rst vrlo vss
*.PININFO vramp:O vss:B vrlo:I rst:I
XRST vramp rst vrlo vss nfet_03v3 L=0.28u W=0.500u nf=1
XCR vramp vss cap_mim_2f0_m4m5_noshield c_width=5.000u c_length=5.000u m=73
.ends

* expanding   symbol:  atop_cell.sym # of pins=14
** sym_path: /foss/designs/mixed_signal/Analog_top/atop_cell.sym
** sch_path: /foss/designs/mixed_signal/Analog_top/atop_cell.sch
.subckt atop_cell vfe vramp s0 s1 s2 vref vbl ibias q clk vdd vss dvdd dvss
*.PININFO vfe:I vramp:I s0:I s1:I s2:I vref:I vbl:I ibias:I q:O clk:I vdd:B vss:B dvdd:B dvss:B
XI0P s0b s0 vdd vdd pfet_03v3 L=0.28u W=0.88u nf=1
XI0N s0b s0 vss vss nfet_03v3 L=0.28u W=0.44u nf=1
XI1P s1b s1 vdd vdd pfet_03v3 L=0.28u W=0.88u nf=1
XI1N s1b s1 vss vss nfet_03v3 L=0.28u W=0.44u nf=1
XI2P s2b s2 vdd vdd pfet_03v3 L=0.28u W=0.88u nf=1
XI2N s2b s2 vss vss nfet_03v3 L=0.28u W=0.44u nf=1
XS2 vref bot s2 s2b vdd vss sw_s2
XS0 vfe top s0 s0b vdd vss sw_s0
XS1 vramp top s1 s1b vdd vss sw_s1
XCS bot top cap_mim_2f0_m4m5_noshield c_width=5u c_length=5u
XCMP vbl bot ibias dout vdd vss comparator_d
XFF dout clk q dvdd dvss latch
.ends

* expanding   symbol:  sample_seq.sym # of pins=16
** sym_path: /foss/designs/mixed_signal/sample_seq/sample_seq.sym
** sch_path: /foss/designs/mixed_signal/sample_seq/sample_seq.sch
.subckt sample_seq acq clk s2_0 s2_1 s2_2 s2_3 s0_0 s0_1 s0_2 s0_3 s1_0 s1_1 s1_2 s1_3 vdd vss
*.PININFO acq:I clk:I s2_0:O s2_1:O s2_2:O s2_3:O s0_0:O s0_1:O s0_2:O s0_3:O s1_0:O s1_1:O s1_2:O s1_3:O vdd:B vss:B
XEN vdd vdd vss vss done_0 done_1 done_2 done_3 en gf180mcu_as_sc_mcu7t3v3__nand4_2
XLG vdd vdd vss vss clk en en_l gf180mcu_as_sc_mcu7t3v3__dlxtn_2
XAG vdd vdd vss vss en_l clk gclk gf180mcu_as_sc_mcu7t3v3__and2_2
XB0 vdd vdd vss vss gclk c0 gf180mcu_as_sc_mcu7t3v3__clkbuff_4
XL1 c0 c5r vdd vss seq_dly
XB5 vdd vdd vss vss c5r c5 gf180mcu_as_sc_mcu7t3v3__clkbuff_4
XL2 c5 c10r vdd vss seq_dly
XB10 vdd vdd vss vss c10r c10 gf180mcu_as_sc_mcu7t3v3__clkbuff_4
XC0 acq c0 c5 c10 s2_0 s0_0 s1_0 done_0 vdd vss seq_cell
XC1 s2_0 c0 c5 c10 s2_1 s0_1 s1_1 done_1 vdd vss seq_cell
XC2 s2_1 c0 c5 c10 s2_2 s0_2 s1_2 done_2 vdd vss seq_cell
XC3 s2_2 c0 c5 c10 s2_3 s0_3 s1_3 done_3 vdd vss seq_cell
.ends

* expanding   symbol:  sw_s2.sym # of pins=6
** sym_path: /foss/designs/mixed_signal/Analog_top/sw_s2.sym
** sch_path: /foss/designs/mixed_signal/Analog_top/sw_s2.sch
.subckt sw_s2 a b ctl ctlb vdd vss
*.PININFO ctl:I ctlb:I a:B b:B vdd:B vss:B
XN b ctl a vss nfet_03v3 L=0.28u W=0.36u nf=1 m=1 ad=0.1584p as=0.1584p pd=1.60u ps=1.60u
.ends

* expanding   symbol:  sw_s0.sym # of pins=6
** sym_path: /foss/designs/mixed_signal/Analog_top/sw_s0.sym
** sch_path: /foss/designs/mixed_signal/Analog_top/sw_s0.sch
.subckt sw_s0 a b ctl ctlb vdd vss
*.PININFO ctl:I ctlb:I a:B b:B vdd:B vss:B
XN b ctl a vss nfet_03v3 L=0.28u W=0.50u nf=1 m=1 ad=0.2200p as=0.2200p pd=1.88u ps=1.88u
XP b ctlb a vdd pfet_03v3 L=0.28u W=1.00u nf=1 m=1 ad=0.4400p as=0.4400p pd=2.88u ps=2.88u
.ends

* expanding   symbol:  sw_s1.sym # of pins=6
** sym_path: /foss/designs/mixed_signal/Analog_top/sw_s1.sym
** sch_path: /foss/designs/mixed_signal/Analog_top/sw_s1.sch
.subckt sw_s1 a b ctl ctlb vdd vss
*.PININFO ctl:I ctlb:I a:B b:B vdd:B vss:B
XN b ctl a vss nfet_03v3 L=0.28u W=0.50u nf=1 m=1 ad=0.2200p as=0.2200p pd=1.88u ps=1.88u
XP b ctlb a vdd pfet_03v3 L=0.28u W=1.00u nf=1 m=1 ad=0.4400p as=0.4400p pd=2.88u ps=2.88u
.ends

* expanding   symbol:  comparator_d.sym # of pins=6
** sym_path: /foss/designs/mixed_signal/Analog_top/comparator_d.sym
** sch_path: /foss/designs/mixed_signal/Analog_top/comparator_d.sch
.subckt comparator_d inp inn ibias dout vdd vss
*.PININFO vdd:B vss:B ibias:I inp:I inn:I dout:O
XTAIL tail ibias vdd vdd pfet_03v3 L=0.28u W=11u nf=11 ad='int((nf+1)/2) * W/nf * 0.18u' as='int((nf+2)/2) * W/nf * 0.18u' pd='2*int((nf+1)/2) * (W/nf + 0.18u)'
+ ps='2*int((nf+2)/2) * (W/nf + 0.18u)' nrd='0.18u / W' nrs='0.18u / W' sa=0 sb=0 sd=0
XINP left inp tail vdd pfet_03v3 L=0.32u W=12u nf=12 ad='int((nf+1)/2) * W/nf * 0.18u' as='int((nf+2)/2) * W/nf * 0.18u' pd='2*int((nf+1)/2) * (W/nf + 0.18u)'
+ ps='2*int((nf+2)/2) * (W/nf + 0.18u)' nrd='0.18u / W' nrs='0.18u / W' sa=0 sb=0 sd=0
XINN outa inn tail vdd pfet_03v3 L=0.32u W=12u nf=12 ad='int((nf+1)/2) * W/nf * 0.18u' as='int((nf+2)/2) * W/nf * 0.18u' pd='2*int((nf+1)/2) * (W/nf + 0.18u)'
+ ps='2*int((nf+2)/2) * (W/nf + 0.18u)' nrd='0.18u / W' nrs='0.18u / W' sa=0 sb=0 sd=0
XLOADD left left vss vss nfet_03v3 L=0.36u W=0.5u nf=1 ad='int((nf+1)/2) * W/nf * 0.18u' as='int((nf+2)/2) * W/nf * 0.18u' pd='2*int((nf+1)/2) * (W/nf + 0.18u)'
+ ps='2*int((nf+2)/2) * (W/nf + 0.18u)' nrd='0.18u / W' nrs='0.18u / W' sa=0 sb=0 sd=0
XLOADM outa left vss vss nfet_03v3 L=0.36u W=0.5u nf=1 ad='int((nf+1)/2) * W/nf * 0.18u' as='int((nf+2)/2) * W/nf * 0.18u' pd='2*int((nf+1)/2) * (W/nf + 0.18u)'
+ ps='2*int((nf+2)/2) * (W/nf + 0.18u)' nrd='0.18u / W' nrs='0.18u / W' sa=0 sb=0 sd=0
XBST bst ibias vdd vdd pfet_03v3 L=0.28u W=5u nf=5 ad='int((nf+1)/2) * W/nf * 0.18u' as='int((nf+2)/2) * W/nf * 0.18u' pd='2*int((nf+1)/2) * (W/nf + 0.18u)'
+ ps='2*int((nf+2)/2) * (W/nf + 0.18u)' nrd='0.18u / W' nrs='0.18u / W' sa=0 sb=0 sd=0
XBUF2 outb outa bst vdd pfet_03v3 L=0.36u W=1u nf=1 ad='int((nf+1)/2) * W/nf * 0.18u' as='int((nf+2)/2) * W/nf * 0.18u' pd='2*int((nf+1)/2) * (W/nf + 0.18u)'
+ ps='2*int((nf+2)/2) * (W/nf + 0.18u)' nrd='0.18u / W' nrs='0.18u / W' sa=0 sb=0 sd=0
XBUF1 outb outa vss vss nfet_03v3 L=0.36u W=0.5u nf=1 ad='int((nf+1)/2) * W/nf * 0.18u' as='int((nf+2)/2) * W/nf * 0.18u' pd='2*int((nf+1)/2) * (W/nf + 0.18u)'
+ ps='2*int((nf+2)/2) * (W/nf + 0.18u)' nrd='0.18u / W' nrs='0.18u / W' sa=0 sb=0 sd=0
XBUF4 dout outb vdd vdd pfet_03v3 L=0.36u W=1u nf=1 ad='int((nf+1)/2) * W/nf * 0.18u' as='int((nf+2)/2) * W/nf * 0.18u' pd='2*int((nf+1)/2) * (W/nf + 0.18u)'
+ ps='2*int((nf+2)/2) * (W/nf + 0.18u)' nrd='0.18u / W' nrs='0.18u / W' sa=0 sb=0 sd=0
XBUF3 dout outb vss vss nfet_03v3 L=0.36u W=0.5u nf=1 ad='int((nf+1)/2) * W/nf * 0.18u' as='int((nf+2)/2) * W/nf * 0.18u' pd='2*int((nf+1)/2) * (W/nf + 0.18u)'
+ ps='2*int((nf+2)/2) * (W/nf + 0.18u)' nrd='0.18u / W' nrs='0.18u / W' sa=0 sb=0 sd=0
XREFP ibias ibias vdd vdd pfet_03v3 L=0.28u W=1u nf=1 ad='int((nf+1)/2) * W/nf * 0.18u' as='int((nf+2)/2) * W/nf * 0.18u' pd='2*int((nf+1)/2) * (W/nf + 0.18u)'
+ ps='2*int((nf+2)/2) * (W/nf + 0.18u)' nrd='0.18u / W' nrs='0.18u / W' sa=0 sb=0 sd=0
.ends

* expanding   symbol:  latch.sym # of pins=5
** sym_path: /foss/designs/mixed_signal/Analog_top/latch.sym
** sch_path: /foss/designs/mixed_signal/latch/latch.sch
.subckt latch d clk q vdd vss
*.PININFO vdd:B vss:B d:I clk:I q:O
XFF vdd vdd vss vss clk d q gf180mcu_as_sc_mcu7t3v3__dfxtn_2
.ends

* expanding   symbol:  seq_dly.sym # of pins=4
** sym_path: /foss/designs/mixed_signal/sample_seq/seq_dly.sym
** sch_path: /foss/designs/mixed_signal/sample_seq/seq_dly.sch
.subckt seq_dly a y vdd vss
*.PININFO a:I y:O vdd:B vss:B
XD1 vdd vdd vss vss d1 a gf180mcu_as_sc_mcu7t3v3__dlybuff_2
XD2 vdd vdd vss vss d2 d1 gf180mcu_as_sc_mcu7t3v3__dlybuff_2
XD3 vdd vdd vss vss d3 d2 gf180mcu_as_sc_mcu7t3v3__dlybuff_2
XD4 vdd vdd vss vss d4 d3 gf180mcu_as_sc_mcu7t3v3__dlybuff_2
XD5 vdd vdd vss vss d5 d4 gf180mcu_as_sc_mcu7t3v3__dlybuff_2
XD6 vdd vdd vss vss d6 d5 gf180mcu_as_sc_mcu7t3v3__dlybuff_2
XD7 vdd vdd vss vss d7 d6 gf180mcu_as_sc_mcu7t3v3__dlybuff_2
XD8 vdd vdd vss vss d8 d7 gf180mcu_as_sc_mcu7t3v3__dlybuff_2
XD9 vdd vdd vss vss d9 d8 gf180mcu_as_sc_mcu7t3v3__dlybuff_2
XD10 vdd vdd vss vss d10 d9 gf180mcu_as_sc_mcu7t3v3__dlybuff_2
XD11 vdd vdd vss vss d11 d10 gf180mcu_as_sc_mcu7t3v3__dlybuff_2
XD12 vdd vdd vss vss d12 d11 gf180mcu_as_sc_mcu7t3v3__dlybuff_2
XD13 vdd vdd vss vss d13 d12 gf180mcu_as_sc_mcu7t3v3__dlybuff_2
XD14 vdd vdd vss vss d14 d13 gf180mcu_as_sc_mcu7t3v3__dlybuff_2
XD15 vdd vdd vss vss d15 d14 gf180mcu_as_sc_mcu7t3v3__dlybuff_2
XD16 vdd vdd vss vss d16 d15 gf180mcu_as_sc_mcu7t3v3__dlybuff_2
XD17 vdd vdd vss vss d17 d16 gf180mcu_as_sc_mcu7t3v3__dlybuff_2
XD18 vdd vdd vss vss d18 d17 gf180mcu_as_sc_mcu7t3v3__dlybuff_2
XD19 vdd vdd vss vss d19 d18 gf180mcu_as_sc_mcu7t3v3__dlybuff_2
XD20 vdd vdd vss vss d20 d19 gf180mcu_as_sc_mcu7t3v3__dlybuff_2
XD21 vdd vdd vss vss d21 d20 gf180mcu_as_sc_mcu7t3v3__dlybuff_2
XD22 vdd vdd vss vss y d21 gf180mcu_as_sc_mcu7t3v3__dlybuff_2
.ends

* expanding   symbol:  seq_cell.sym # of pins=10
** sym_path: /foss/designs/mixed_signal/sample_seq/seq_cell.sym
** sch_path: /foss/designs/mixed_signal/sample_seq/seq_cell.sch
.subckt seq_cell tin c0 c5 c10 s2 s0 s1 done vdd vss
*.PININFO tin:I c0:I c5:I c10:I s2:O s0:O s1:O done:B vdd:B vss:B
XFA vdd vdd vss vss c0 tin s2 gf180mcu_as_sc_mcu7t3v3__dfxtp_2
XFB vdd vdd vss vss c5 s2 s0 gf180mcu_as_sc_mcu7t3v3__dfxtp_2
XFC vdd vdd vss vss c10 s0 qc gf180mcu_as_sc_mcu7t3v3__dfxtp_2
XNR vdd vdd vss vss s1 qc s2 gf180mcu_as_sc_mcu7t3v3__nor2_2
XX1 vdd vdd vss vss s2 tin x1 gf180mcu_as_sc_mcu7t3v3__xor2_2
XX2 vdd vdd vss vss s0 s2 x2 gf180mcu_as_sc_mcu7t3v3__xor2_2
XX3 vdd vdd vss vss qc s0 x3 gf180mcu_as_sc_mcu7t3v3__xor2_2
XND vdd vdd vss vss x1 x2 x3 done gf180mcu_as_sc_mcu7t3v3__nor3_2
.ends
