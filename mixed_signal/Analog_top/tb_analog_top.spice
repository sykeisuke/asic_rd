* tb_analog_top -- one four-cell record of the analog macro (v7) from a cold
* supply: power-up, the four samples (40 ns apart), the shared ramp and the four
* trips. The macro is analog_top.spice, GENERATED from analog_top.sch by
* schematic.sh: every block down to transistors, as drawn. The macro (ONE VDD/2 buffer for vref, ADR 0021) has every analog
* block of the ADC inside, vrlo included (vrlo_ref, biased by bias_gen_s):
* the ONLY ideal sources are the supplies, the input, the switch controls,
* ramp_rst and the count clock. The latch latch is the standard cell
* gf180mcu_as_sc_mcu7t3v3__dfxtn_2, its extracted netlist from the library.
* No block deck and no parameter file is included: analog_top.spice is
* self-contained apart from the PDK models and the standard-cell library.
* Timeline and levels: tb_params.inc (TR = TS3 + 300 ns, vrlo_ref's
* requirement, ADR 0018). Measures, analysis and output: tb_measure.inc.
* The xschem testbench tb_analog_top.sch draws this circuit.
*
* Run from a directory holding .spiceinit (set num_threads=1):
*   ngspice -b /foss/designs/mixed_signal/Analog_top/tb_analog_top.spice
.include /foss/pdks/gf180mcuD/libs.tech/ngspice/design.ngspice
.lib /foss/pdks/gf180mcuD/libs.tech/ngspice/sm141064.ngspice typical
.lib /foss/pdks/gf180mcuD/libs.tech/ngspice/sm141064.ngspice res_typical
.lib /foss/pdks/gf180mcuD/libs.tech/ngspice/sm141064.ngspice mimcap_typical
* the latch's standard cell (full library install of the pinned commit, make pdk-libs)
.include /foss/pdk_libs/gf180mcuD/libs.ref/gf180mcu_as_sc_mcu7t3v3/spice/gf180mcu_as_sc_mcu7t3v3.spice
.include /foss/designs/mixed_signal/Analog_top/analog_top.spice
.include /foss/designs/mixed_signal/Analog_top/tb_params.inc

* ---------------------------------------------------------------------------
* Simulation aid, testbench only: a 1e15 ohm resistor from EVERY node to ground.
* Each cell's bottom plate (S2 / comparator inn) floats from S2 opening to the
* end of the record, and at t = 0 every switch is open (the controls start at
* 0 V), so both plates of every MIM have no DC path at the initial operating
* point. The macro carries no leak resistor (since v3); the simulator adds the
* conductance (1e-15 S). 1e-15 S x 3.3 V = 3.3 fA, five decades below every
* bias current in the macro.
* ---------------------------------------------------------------------------
.options rshunt=1e15

* ---------------------------------------------------------------------------
* Supplies (cold start), input, ramp reset, count clock, switch controls
* ---------------------------------------------------------------------------
VAVDD avdd 0 PWL(0 0 {TPWR} {VDD})
VDVDD dvdd 0 PWL(0 0 {TPWR} {VDD})
* one level per cell; vin steps TSTEP after each S2 opens (S0_k is open by then)
VVIN vin 0 PWL(0 {VIN0} {TS0+TSTEP} {VIN0} {TS0+TSTEP+TEDGE} {VIN1} {TS1+TSTEP} {VIN1} {TS1+TSTEP+TEDGE} {VIN2} {TS2+TSTEP} {VIN2} {TS2+TSTEP+TEDGE} {VIN3})
VRST ramp_rst 0 PWL(0 0 {TPWR} {VDD} {TR} {VDD} {TR+TEDGE} 0)
* 20 MHz count clock, free-running, a rising edge at TR; the latch samples on falling edges
VCLK cnt_clk 0 PULSE(0 {VDD} {TCLK0} {TEDGE} {TEDGE} {TCOUNT/2-TEDGE} {TCOUNT})
* acq, the controller's acquire level: high (track) from power-up, falls 2 ns after
* the clock edge before TS0; the sequencer in the macro makes the switch controls
VACQ acq 0 PWL(0 0 {TPWR} {VDD} {TACQ} {VDD} {TACQ+TEDGE} 0)

* ---------------------------------------------------------------------------
* The macro and the capture load on each q
* ---------------------------------------------------------------------------
XDUT vin ramp_rst cnt_clk acq q0 q1 q2 q3 avdd 0 dvdd 0 analog_top
CQ0 q0 0 {CQ}
CQ1 q1 0 {CQ}
CQ2 q2 0 {CQ}
CQ3 q3 0 {CQ}

.include /foss/designs/mixed_signal/Analog_top/tb_measure.inc
.end
