* cmp_updt -- continuous comparator for the TRUE BOTTOM-PLATE 8-bit cell:
* PMOS 5T OTA -> starved inverter -> output inverter (10 devices).
* inp = VBL = VDD/2 (the only decision common mode), inn = the top plate of
* the 54.52 fF MIM. dout is HIGH before the crossing and FALLS when inn rises
* through inp. clk and nbias are NO-CONNECTS: the port list is the contract's
* (../Analog_top_bkp/unit_cell_bps/CONTRACT.md) and no device touches them.
*
* GENERATED by size_updt.py (seed 20260918, 150000 + 4 x 30000 samples,
* margin 1.0, dead-zone relax 1.0). Do not hand-edit: run.sh
* regenerates it into work/ and fails if this file differs. To change the
* sizing, change the recipe (DESIGN_RECIPE.md). Specification: SPEC.md.
* Topology evidence: ablation/ABLATION.md (runs/comparator-ablation/
* 20261002T091034Z): the earlier clamp, its V_left replica and the explicit
* 20 fF COUTA were removed; the earlier netlist is ablation/cmp_v0.spice.
* No explicit capacitor: the outa/outb wiring is an ASSUMED 5 / 2 fF in the
* model only, and extraction (PEX) replaces it.
*
* Labels: [D] derived, [P] PDK tables/liberty, [M] measured, [A] assumed.
* gm/Id operating point at VCM = 1.65 V, the power x area knee of the front [P]:
*   input pair  gm/Id 14.09 S/A, L 0.6 um -> W 3.1 um, nf 1
*               CGG 6.5 fF, CGD 0.42 fF at the decision point
*   mirror load gm/Id 17.19 S/A, L 2.0 um -> W 6.7 um, nf 2
*   tail        gm/Id 15.04 S/A (the fixed reference leg's), L 1.0 um -> W 14.9 um, nf 4
*   starve      1.755 uA (1.50 x I_branch) pbias mirror -> W 11.2 um at L 1 um
*   XBUF1       trips at V_left + 0.150 V = 0.835 V -> W 0.5 um at L 0.5 um
*   XBUF2       fixed 1.0 / 0.28 um; off before the trip by 103 mV (outa rests at V_tail 2.68 V)
*   output inv  N 0.44 / P 0.44 um at L 0.28 um, driving 43.5 fF
*               (10 dffrnq_1 CLK pins [P] + 10 fF wire [A]); sized by its own RC (a quarter of
*               4.3 ns, half the liberty max_transition 8.6 ns [P,A]); the dout
*               edge itself is gated in the cell bench (the closed form reads 4-5x fast)
*   branch current 1.170 uA, OTA gain 216.5 V/V, tau_out 207 ns (C_outa 15.8 fF)
*   power 13.5 uW worst static state ((2 I_branch + I_starve) x VDD), 7.7 uW waiting
*   for the crossing, 23.9 uW at 1.77x bias (budget 50 uW [A]); sized gate area 57.2 um2
*   BIAS: IREF = 3.1314 uA into the L=1u W=20u reference leg, FIXED by ../bias_gen_bkp/bias_gen
*   (tail mirror ratio 0.747). Tail headroom at the decision 620 mV
*   (Vdsat 133 mV); at 1.77x bias 575 mV, and 425 mV at VDD = 3.0 V
*   (Vdsat 158 mV; gate Vdsat + 0.2 V).
* Bottom-plate figures, predicted at typical (C_S 54.52 fF, C_top 8.1 fF):
*   alpha 0.871; at the ADC input: noise 0.012 LSB rms (budget 0.2 [A]),
*   sigma(Vos) 1.20 LSB (pins: 60 uV, 6.12 mV), static offset 0.14 LSB;
*   Cgd charge bound 2.14 LSB; S2 1.2 LSB [M]; delay 132 ns; pedestal bound
*   6.12 LSB (budget 8), +3 sigma 9.7 counts (overrun 19);
*   dead zone 0.58 LSB nominal (budget 1 x relax 1.0), ~4.2 LSB at a -3 sigma cell;
*   low-end delay deviation (model, pessimistic): c4 +0.007 LSB, -0.067 with 10 fF more on
*   outa (gate 0.1 [A]); codes 1/2/3 -1.38/-0.68/-0.23 LSB (need a ramp pre-roll).
* The simulators are the authority, not these lines.
.subckt cmp inp inn dout clk vdd vss nbias pbias
XINP left inp tail vdd pfet_03v3 L=0.6u W=3.1u nf=1 m=1
XINN outa inn tail vdd pfet_03v3 L=0.6u W=3.1u nf=1 m=1
XLOADD left left vss vss nfet_03v3 L=2.0u W=6.7u nf=2 m=1
XLOADM outa left vss vss nfet_03v3 L=2.0u W=6.7u nf=2 m=1
XTAIL tail pbias vdd vdd pfet_03v3 L=1.0u W=14.9u nf=4 m=1
XBST bst pbias vdd vdd pfet_03v3 L=1.0u W=11.2u nf=3 m=1
XBUF1 outb outa vss vss nfet_03v3 L=0.5u W=0.5u nf=1 m=1
XBUF2 outb outa bst vdd pfet_03v3 L=0.28u W=1.0u nf=1 m=1
XBUF3 dout outb vss vss nfet_03v3 L=0.28u W=0.44u nf=1 m=1
XBUF4 dout outb vdd vdd pfet_03v3 L=0.28u W=0.44u nf=1 m=1
.ends cmp
