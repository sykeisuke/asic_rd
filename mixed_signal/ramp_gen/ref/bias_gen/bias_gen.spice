* Shared bias generator for the bottom-plate unit cell: one constant-gm core
* for the comparator's pbias and, through pbias slaves, the two FVF VDD/2
* buffers (VREF, VBL). Configuration S of RESULTS.md section 7.
*
* Sizes come from data/bias_gen_params.spice (written by size_bias_gen.py);
* this file carries only topology. Every MOS is nfet_03v3 / pfet_03v3.
*
* Two subcircuits:
*
*   bias_gen      vdd vss pbias nbias          THE DESIGN (configuration S)
*   bias_ws_legs  vdd vss pbias vb1..vb4       the wide-swing legs of the
*                                              exploration (configuration C),
*                                              kept so the recorded 135-cell
*                                              comparison reproduces; the
*                                              unit cell does not use them
*
* Ports of bias_gen
*   vdd vss  analog supply (3.3 V nominal) and ground
*   pbias    PMOS gate line. XMP2 is the diode-connected L=1u W=20u nf=10
*            leg that cmp_bps's recipe FIXES at 3.1314 uA
*            (../comparator_bkp/comparator_lp/cmp_bps.spice header, "BIAS: IREF = 3.1314 uA
*            into the L=1u W=20u reference leg, FIXED by ../bias_gen_bkp/bias_gen"), so
*            the comparator on this line mirrors it exactly as its benches
*            assume. The FVF buffers take their IB from pbias slaves
*            (pfet_03v3 L=1u W=BG_WSL nf=BG_NFSL, 1.00 uA each into the
*            buffer's own NMOS diode): ../midrail_ref_bkp/midrail_ref/ref_fvf_biased.spice.
*   nbias    the core's NMOS diode node, exported: the startup disengage
*            senses it, and cmp_bps's port list has an nbias pin (unused
*            inside the comparator)
*
* 1. Core: the beta multiplier of ../bias_gen_bkp/bias_reference (1:1 PMOS mirror over a
*    1:K degenerated NMOS pair, ppolyf_u resistor), re-centred on the
*    comparator's current. It holds gm*R, not the current
*    (../bias_gen_bkp/bias_reference/RESULTS.md); the recorded spread over PVT is
*    0.69x .. 1.77x, which cmp_bps's recipe sizes its headroom against.
* 2. Startup: the same three-diode bleeder, kick and nbias-driven
*    disengage as ../bias_gen_bkp/bias_reference. XSU4's gate is nbias, so the startup
*    turns itself off only once the loop it started is running.
* 3. Decoupling: XCP is a PMOS gate capacitor from pbias to vdd (~0.9 pF).
*    Tying it to vdd, not vss, holds VSG of every PMOS on the line against
*    supply steps and absorbs the charge the comparator's tail and starve
*    devices kick into pbias at the decision.
*
* bias_ws_legs (Baker's wide-swing arrangement, exploration only):
*      XS3 -> XNW              NMOS "MWS" diode:  vb3 = VGS(cascode) + VDS(mirror)
*      XS4 -> XN4C / XN4M      cascode-diode:     vb4 = VGS(mirror)
*      XPW <- XN2C / XN2M      PMOS "MWS" diode:  vb2 = VDD - VSG(cascode) - VSD(mirror)
*      XP1M / XP1C <- XN1C / XN1M   cascode-diode: vb1 = VDD - VSG(mirror)
*    XS3 and XS4 are slaves of pbias at IU = FVF_IREF; the two PMOS legs are
*    fed by NMOS cascode sinks biased by vb3/vb4, so four legs of IU each.
*    RESULTS.md section 4: no measured figure of either load improves with
*    them, and they cost 4 uA, 13.2 uW and ~610 um2.
*
* PROBES: xmp1 xmp2 xmn1 xmn2
* PROBES-WS: xs3 xs4 xn4c xn4m xn2c xn2m xp1m xp1c xn1c xn1m
.subckt bias_gen vdd vss pbias nbias
* ---- 1. core
XMP1 nbias pbias vdd vdd pfet_03v3 L=1.0u W=20.0u nf=10 m=1
XMP2 pbias pbias vdd vdd pfet_03v3 L=1.0u W=20.0u nf=10 m=1
XMN1 nbias nbias vss vss nfet_03v3 L={BG_LN} W={BG_W1} nf={BG_NF1} m=1
XMN2 pbias nbias ns vss nfet_03v3 L={BG_LN} W={BG_K*BG_W1} nf={BG_K*BG_NF1} m=1
XRDEG ns vss vss ppolyf_u r_width={BG_RW} r_length={BG_RLEN}
* ---- 2. startup
XSU1 sua sua vdd vdd pfet_03v3 L=8.0u W=1.06u nf=1 m=1
XSU2 sub sub sua sua pfet_03v3 L=8.0u W=1.06u nf=1 m=1
XSU3 su su sub sub pfet_03v3 L=8.0u W=1.06u nf=1 m=1
XSU4 su nbias vss vss nfet_03v3 L=1.0u W=0.5u nf=1 m=1
XSU5 pbias su vss vss nfet_03v3 L=1.0u W={BG_WKICK} nf=1 m=1
* ---- 3. decoupling on pbias
XCP vdd pbias vdd vdd pfet_03v3 L={BG_CPL} W={BG_CPW} nf={BG_CPNF} m=1
.ends bias_gen

* ---- exploration only: the wide-swing legs of configuration C
.subckt bias_ws_legs vdd vss pbias vb1 vb2 vb3 vb4
XS3 vb3 pbias vdd vdd pfet_03v3 L=1.0u W={BG_WSL} nf={BG_NFSL} m=1
XNW vb3 vb3 vss vss nfet_03v3 L={BG_LNW} W={BG_WNW} nf=1 m=1
XS4 vb4 pbias vdd vdd pfet_03v3 L=1.0u W={BG_WSL} nf={BG_NFSL} m=1
XN4C vb4 vb3 n4m vss nfet_03v3 L={BG_LNC} W={BG_WNC} nf=1 m=1
XN4M n4m vb4 vss vss nfet_03v3 L={BG_LNM} W={BG_WNM} nf=1 m=1
XPW vb2 vb2 vdd vdd pfet_03v3 L={BG_LPW} W={BG_WPW} nf=1 m=1
XN2C vb2 vb3 n2m vss nfet_03v3 L={BG_LNC} W={BG_WNC} nf=1 m=1
XN2M n2m vb4 vss vss nfet_03v3 L={BG_LNM} W={BG_WNM} nf=1 m=1
XP1M p1m vb1 vdd vdd pfet_03v3 L={BG_LPM} W={BG_WPM} nf={BG_NFPM} m=1
XP1C vb1 vb2 p1m vdd pfet_03v3 L={BG_LPC} W={BG_WPC} nf=1 m=1
XN1C vb1 vb3 n1m vss nfet_03v3 L={BG_LNC} W={BG_WNC} nf=1 m=1
XN1M n1m vb4 vss vss nfet_03v3 L={BG_LNM} W={BG_WNM} nf=1 m=1
.ends bias_ws_legs
