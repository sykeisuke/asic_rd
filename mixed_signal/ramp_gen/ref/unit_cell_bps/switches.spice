* Switches of the true bottom-plate unit cell (mixed_signal/Analog_top_bkp/unit_cell_bps).
*
* GENERATED by switches/size_switches.py from recorded figures; do not
* hand-edit: switches/run.sh regenerates it into work/ and fails if this
* file differs. The derivation is switches/SWITCH_SIZING.md.
*
* Ports (CONTRACT.md): a = driving side, b = plate side, ctl HIGH = closed,
* ctlb its complement (made inside the cell), vdd vss the supplies.
* No model lines here: the including deck carries the PDK includes.
* Junctions are drawn at the DRC-minimum contacted geometry (ad = W x
* 0.44 um, pd = 2 (W + 0.44 um)) so their capacitance is in the simulation.
*
* S0 vfe -> bot   TG k=2: NMOS 0.50/0.28, PMOS 1.00/0.28.
*                 R_on,max 5.59 kohm over 0.5-2.0 V (typical), tau 313 ps
*                 against the 650 ps tracking budget (2.1x margin).
* S1 vramp -> bot same device: ramp lag R_on C_bot 7040.22 nV, signal-dependent part 2657.31 nV.
* S2 vref -> top  single NMOS 0.36/0.28 (contacted minimum) at VDD/2: R_on 9.9 kohm, tau 656 ps;
*                 predicted pedestal 0.93 LSB at the ADC input (budget 6.2),
*                 droop 0.368 mLSB over the conversion, C_top +0.63 fF (alpha 0.830 -> 0.822).
* The simulators are the authority, not these lines.

.subckt sw_s0 a b ctl ctlb vdd vss
XN b ctl a vss nfet_03v3 L=0.28u W=0.50u nf=1 m=1 ad=0.2200p as=0.2200p pd=1.88u ps=1.88u
XP b ctlb a vdd pfet_03v3 L=0.28u W=1.00u nf=1 m=1 ad=0.4400p as=0.4400p pd=2.88u ps=2.88u
.ends sw_s0

.subckt sw_s1 a b ctl ctlb vdd vss
XN b ctl a vss nfet_03v3 L=0.28u W=0.50u nf=1 m=1 ad=0.2200p as=0.2200p pd=1.88u ps=1.88u
XP b ctlb a vdd pfet_03v3 L=0.28u W=1.00u nf=1 m=1 ad=0.4400p as=0.4400p pd=2.88u ps=2.88u
.ends sw_s1

.subckt sw_s2 a b ctl ctlb vdd vss
* ctlb is in the port list for uniformity and is not used: one device, one aperture edge
XN b ctl a vss nfet_03v3 L=0.28u W=0.36u nf=1 m=1 ad=0.1584p as=0.1584p pd=1.60u ps=1.60u
.ends sw_s2
