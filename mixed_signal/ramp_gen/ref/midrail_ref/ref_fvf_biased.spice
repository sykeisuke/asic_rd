* midref_b -- option C of this block (class-AB buffer from two flipped voltage
* followers, ppolyf_u_3k divider) with its ideal IREF replaced by one pbias
* slave of the shared constant-gm generator (../bias_gen_bkp/bias_gen, variant "simple").
*
* GENERATED by make_biased.py from ref_fvf.spice, data/midrail_params.spice
* and ../bias_gen_bkp/bias_gen/data/bias_gen_params.spice. Do not hand-edit: run-biased.sh
* regenerates it and fails if this file differs. Sizes are written literally
* so that `.include` of this one file is the whole dependency.
*
* Ports: out   the VDD/2 output (VREF or VBL of the unit cell)
*        pbias the generator's PMOS gate line (3.131 uA into L=1u W=20u nf=10)
*        vdd vss
* Bias:  XSLF mirrors pbias at 6.07/1 nf 3 -> 1.0 uA into the FVF's NMOS diode
*        XMBN (bisected in ../bias_gen_bkp/bias_gen; 1.0002 uA at typical). The FVF then
*        sees exactly the IB it was sized for in data/SIZING.md.
* Every FVF device, the divider and the 1 pF tap capacitor are unchanged.
* The two zero-valued compensation capacitors of ref_fvf.spice are omitted.
* PROBES: xslf xmit xmib xm1 xm3 xm4 xm6 xm2 xm5
.subckt midref_b out pbias vdd vss
* ---- VDD/2 divider (two identical ppolyf_u_3k halves, body on vss)
XRT vdd vin vss ppolyf_u_3k r_width=1u r_length=550u
XRB vin vss vss ppolyf_u_3k r_width=1u r_length=550u
CFLT vin vss 1p
* ---- bias: pbias slave (the generator's XS3/XS4 geometry) -> NMOS diode
*      -> NMOS mirror -> PMOS diode. Delivers FVF_IREF = 1 uA (bias_gen SIZING.md).
XSLF nb pbias vdd vdd pfet_03v3 L=1.0u W=6.07u nf=3 m=1
XMBN  nb  nb  vss vss nfet_03v3 L=4u W=2u nf=1 m=1
XMBN2 pb  nb  vss vss nfet_03v3 L=4u W=2u nf=1 m=1
XMBP  pb  pb  vdd vdd pfet_03v3 L=4u W=16u nf=1 m=1
* ---- the two IB sources
XMIT  a   pb  vdd vdd pfet_03v3 L=4u W=16u nf=1 m=1
XMIB  b   nb  vss vss nfet_03v3 L=4u W=2u nf=1 m=1
* ---- PMOS flipped voltage follower and its output diode
XM3 p   b   vdd vdd pfet_03v3 L=2u W=2u nf=1 m=1
XM1 b   vin p   vdd pfet_03v3 L=2u W=8u nf=1 m=1
XM2 out out p   vdd pfet_03v3 L=2u W=32u nf=4 m=1
* ---- NMOS flipped voltage follower and its output diode
XM6 n   a   vss vss nfet_03v3 L=8u W=1u nf=1 m=1
XM4 a   vin n   vss nfet_03v3 L=2u W=8u nf=1 m=1
XM5 out out n   vss nfet_03v3 L=2u W=32u nf=4 m=1
.ends midref_b
