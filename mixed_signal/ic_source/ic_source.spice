* ic_source -- the I/C current source of the 8-bit ADC's ramp (SPEC.md, DESIGN_RECIPE.md).
* I = C_UNIT x V_REF x F_CLK = 54.52 fF x 0.500 V x 20 MHz = 0.5452 uA: one unit MIM switched at the count
* clock against node a, held at V_REF (tap 5 of 33) by a folded-cascode OTA through the degenerated,
* cascoded pass device XM1; XMO (identical) delivers the current to the ramp. GENERATED by size_ic.py.
* Non-overlapping phases from the frozen standard cells (the bench includes
*   .include /foss/pdk_libs/gf180mcuD/libs.ref/gf180mcu_as_sc_mcu7t3v3/spice/gf180mcu_as_sc_mcu7t3v3.spice
* ); the switch drivers sit on dvdd / dvss like the cells' latches.
* Ports: iout (to vramp), ibias (bias_gen's 3.25 uA ramp sink), clk (cnt_clk), avdd avss dvdd dvss.
.subckt ic_source iout ibias clk avdd avss dvdd dvss
* ---- the reference divider: 33 strips (28 over vref, 5 under); the cascode biases are Vgs-referenced stacks
XRU[27] ru[26] avdd avss ppolyf_u_3k r_width=1u r_length=20u
XRU[26] ru[25] ru[26] avss ppolyf_u_3k r_width=1u r_length=20u
XRU[25] ru[24] ru[25] avss ppolyf_u_3k r_width=1u r_length=20u
XRU[24] ru[23] ru[24] avss ppolyf_u_3k r_width=1u r_length=20u
XRU[23] ru[22] ru[23] avss ppolyf_u_3k r_width=1u r_length=20u
XRU[22] ru[21] ru[22] avss ppolyf_u_3k r_width=1u r_length=20u
XRU[21] ru[20] ru[21] avss ppolyf_u_3k r_width=1u r_length=20u
XRU[20] ru[19] ru[20] avss ppolyf_u_3k r_width=1u r_length=20u
XRU[19] ru[18] ru[19] avss ppolyf_u_3k r_width=1u r_length=20u
XRU[18] ru[17] ru[18] avss ppolyf_u_3k r_width=1u r_length=20u
XRU[17] ru[16] ru[17] avss ppolyf_u_3k r_width=1u r_length=20u
XRU[16] ru[15] ru[16] avss ppolyf_u_3k r_width=1u r_length=20u
XRU[15] ru[14] ru[15] avss ppolyf_u_3k r_width=1u r_length=20u
XRU[14] ru[13] ru[14] avss ppolyf_u_3k r_width=1u r_length=20u
XRU[13] ru[12] ru[13] avss ppolyf_u_3k r_width=1u r_length=20u
XRU[12] ru[11] ru[12] avss ppolyf_u_3k r_width=1u r_length=20u
XRU[11] ru[10] ru[11] avss ppolyf_u_3k r_width=1u r_length=20u
XRU[10] ru[9] ru[10] avss ppolyf_u_3k r_width=1u r_length=20u
XRU[9] ru[8] ru[9] avss ppolyf_u_3k r_width=1u r_length=20u
XRU[8] ru[7] ru[8] avss ppolyf_u_3k r_width=1u r_length=20u
XRU[7] ru[6] ru[7] avss ppolyf_u_3k r_width=1u r_length=20u
XRU[6] ru[5] ru[6] avss ppolyf_u_3k r_width=1u r_length=20u
XRU[5] ru[4] ru[5] avss ppolyf_u_3k r_width=1u r_length=20u
XRU[4] ru[3] ru[4] avss ppolyf_u_3k r_width=1u r_length=20u
XRU[3] ru[2] ru[3] avss ppolyf_u_3k r_width=1u r_length=20u
XRU[2] ru[1] ru[2] avss ppolyf_u_3k r_width=1u r_length=20u
XRU[1] ru[0] ru[1] avss ppolyf_u_3k r_width=1u r_length=20u
XRU[0] vref ru[0] avss ppolyf_u_3k r_width=1u r_length=20u
XRL[4] rl[3] vref avss ppolyf_u_3k r_width=1u r_length=20u
XRL[3] rl[2] rl[3] avss ppolyf_u_3k r_width=1u r_length=20u
XRL[2] rl[1] rl[2] avss ppolyf_u_3k r_width=1u r_length=20u
XRL[1] rl[0] rl[1] avss ppolyf_u_3k r_width=1u r_length=20u
XRL[0] avss rl[0] avss ppolyf_u_3k r_width=1u r_length=20u
XCT vref avss cap_mim_2f0_m4m5_noshield c_width=5.000u c_length=5.000u m=8
* ---- the switched unit capacitor at node a (bottom plate on avss, as the ramp's)
XCU ct avss cap_mim_2f0_m4m5_noshield c_width=5.000u c_length=5.000u m=1
XSA a phi1 ct avss nfet_03v3 L=0.280u W=0.300u nf=1 m=1
XSG ct phi2 avss avss nfet_03v3 L=0.280u W=0.300u nf=1 m=1
XCF a avss cap_mim_2f0_m4m5_noshield c_width=5.000u c_length=5.000u m=4
* ---- non-overlapping phi1 (a <-> ct) / phi2 (ct <-> avss): phi1 = clk & !phi2, phi2 = !clk & !phi1
XI0 dvdd dvdd dvss dvss clkb clk gf180mcu_as_sc_mcu7t3v3__inv_2
XNR1 dvdd dvdd dvss dvss p1 phi2 clkb gf180mcu_as_sc_mcu7t3v3__nor2_2
XNR2 dvdd dvdd dvss dvss p2 phi1 clk gf180mcu_as_sc_mcu7t3v3__nor2_2
XI1 dvdd dvdd dvss dvss p1b p1 gf180mcu_as_sc_mcu7t3v3__inv_2
XI2 dvdd dvdd dvss dvss phi1 p1b gf180mcu_as_sc_mcu7t3v3__inv_2
XI3 dvdd dvdd dvss dvss p2b p2 gf180mcu_as_sc_mcu7t3v3__inv_2
XI4 dvdd dvdd dvss dvss phi2 p2b gf180mcu_as_sc_mcu7t3v3__inv_2
* ---- the pass mirror: 8 strips of degeneration (0.28 V), 16 fingers, cascoded; XM1 feeds node a, XMO the ramp
XRS1[7] s1r[6] avdd avss ppolyf_u_3k r_width=1u r_length=20u
XRS1[6] s1r[5] s1r[6] avss ppolyf_u_3k r_width=1u r_length=20u
XRS1[5] s1r[4] s1r[5] avss ppolyf_u_3k r_width=1u r_length=20u
XRS1[4] s1r[3] s1r[4] avss ppolyf_u_3k r_width=1u r_length=20u
XRS1[3] s1r[2] s1r[3] avss ppolyf_u_3k r_width=1u r_length=20u
XRS1[2] s1r[1] s1r[2] avss ppolyf_u_3k r_width=1u r_length=20u
XRS1[1] s1r[0] s1r[1] avss ppolyf_u_3k r_width=1u r_length=20u
XRS1[0] s1 s1r[0] avss ppolyf_u_3k r_width=1u r_length=20u
XM1 d1 vg s1 avdd pfet_03v3 L=1.000u W=32.000u nf=16 m=1
XM1C a vcasp d1 avdd pfet_03v3 L=0.500u W=8.000u nf=4 m=1
XRS2[7] s2r[6] avdd avss ppolyf_u_3k r_width=1u r_length=20u
XRS2[6] s2r[5] s2r[6] avss ppolyf_u_3k r_width=1u r_length=20u
XRS2[5] s2r[4] s2r[5] avss ppolyf_u_3k r_width=1u r_length=20u
XRS2[4] s2r[3] s2r[4] avss ppolyf_u_3k r_width=1u r_length=20u
XRS2[3] s2r[2] s2r[3] avss ppolyf_u_3k r_width=1u r_length=20u
XRS2[2] s2r[1] s2r[2] avss ppolyf_u_3k r_width=1u r_length=20u
XRS2[1] s2r[0] s2r[1] avss ppolyf_u_3k r_width=1u r_length=20u
XRS2[0] s2 s2r[0] avss ppolyf_u_3k r_width=1u r_length=20u
XMO d2 vg s2 avdd pfet_03v3 L=1.000u W=32.000u nf=16 m=1
XMOC iout vcasp d2 avdd pfet_03v3 L=0.500u W=8.000u nf=4 m=1
* ---- the gate node: compensation (79 units) and the start-up pre-charge (two stacked diodes)
XCG vg avss cap_mim_2f0_m4m5_noshield c_width=5.000u c_length=5.000u m=79
XSU1 su su avdd avdd pfet_03v3 L=0.360u W=0.220u nf=1 m=1
XSU2 vg vg su avdd pfet_03v3 L=0.360u W=0.220u nf=1 m=1
* ---- bias: ibias into a 10-finger diode (bias_gen's ramp sink, XRD's geometry); one-finger copies
XPB ibias ibias avdd avdd pfet_03v3 L=1.000u W=20.000u nf=10 m=1
XPT ts ibias avdd avdd pfet_03v3 L=1.000u W=2.000u nf=1 m=1
XPNB nb ibias avdd avdd pfet_03v3 L=1.000u W=2.000u nf=1 m=1
XNB nb nb avss avss nfet_03v3 L=1.000u W=84.000u nf=42 m=1
* ---- cascode biases: vcasn = Vgs(ND1) + Vgs(ND2 wide); vcasp = avdd - |Vgs(D1 wide)| - |Vgs(D2)|
XPNC vcasn ibias avdd avdd pfet_03v3 L=1.000u W=2.000u nf=1 m=1
XND1 vcasn vcasn ncm avss nfet_03v3 L=0.500u W=1.000u nf=1 m=1
XND2 ncm ncm avss avss nfet_03v3 L=0.500u W=4.000u nf=1 m=1
XPD1 pcm pcm avdd avdd pfet_03v3 L=0.500u W=8.000u nf=4 m=1
XPD2 vcasp vcasp pcm avdd pfet_03v3 L=0.500u W=2.000u nf=1 m=1
XNCS vcasp nb avss avss nfet_03v3 L=1.000u W=56.000u nf=28 m=1
* ---- folded-cascode OTA: PMOS pair (a, vref), NMOS fold sinks, cascodes, cascoded PMOS mirror load; output vg
* ---- (no chopper: pair and sinks sized for sigma(Vos) 1.93 mV = 0.39 % of I)
XIA fh1 a ts avdd pfet_03v3 L=1.000u W=56.000u nf=28 m=1
XIR fh2 vref ts avdd pfet_03v3 L=1.000u W=56.000u nf=28 m=1
XN1 fh1 nb avss avss nfet_03v3 L=1.000u W=56.000u nf=28 m=1
XN2 fh2 nb avss avss nfet_03v3 L=1.000u W=56.000u nf=28 m=1
XNC1 dl vcasn fh1 avss nfet_03v3 L=0.500u W=1.000u nf=1 m=1
XNC2 vg vcasn fh2 avss nfet_03v3 L=0.500u W=1.000u nf=1 m=1
XPL1 sl1 dl avdd avdd pfet_03v3 L=1.000u W=8.000u nf=4 m=1
XPLC1 dl vcasp sl1 avdd pfet_03v3 L=0.500u W=2.000u nf=1 m=1
XPL2 sl2 dl avdd avdd pfet_03v3 L=1.000u W=8.000u nf=4 m=1
XPLC2 vg vcasp sl2 avdd pfet_03v3 L=0.500u W=2.000u nf=1 m=1
.ends ic_source
