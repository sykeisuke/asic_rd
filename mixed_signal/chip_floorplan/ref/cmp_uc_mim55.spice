* P5T sized INTO a 54.52 fF hold capacitor -- unit cell comparator (mim55).
* GENERATED by comparator_unit_cell/size_uc.py driving comparator/size_p5t.py
* with KICK_BUDGET = 1.465 mV x (54.52 fF / 1 pF); nothing else changed.
*
* GENERATED by size_p5t.py (seed 20260916, 40000 samples). Do not
* hand-edit: run.sh regenerates it into work/ and fails if this file differs.
* To change the sizing, change the sizing script.
*
* Same topology, same internal node names and same port list as
* cmp_p5t_ref.spice, so one bench measures both. Only geometry and the tail
* mirror ratio changed.
*
* gm/Id operating point chosen from the Pareto front:
*   input pair  gm/Id 18.73 S/A, L 0.4 um -> W 12.4 um, nf 3
*   mirror load gm/Id 22.13 S/A, L 0.6 um -> W 21.4 um, nf 5
*   tail        gm/Id 16.96 S/A, L 1.0 um -> W 49.6 um, nf 12
*   branch current 2.31 uA, OTA gain 79.1 V/V
*   BIAS: this sizing REQUIRES IREF = 1.87 uA into the testbench's
*   L=1u W=20u reference leg. The tail inherits that leg's VSG, so IREF is
*   what sets Vdsat_tail = 118 mV and hence the headroom at 2.0 V.
*   Running this netlist at the recorded 50 uA puts the tail back in triode.
*   V_left 0.624 V, V_outa 1.504 V, tail headroom at
*   VCM=2.0 V is 381 mV against Vdsat 118 mV
*   input pair n-well on vdd, as recorded: a pure resize, no
*   connectivity change.
* Predicted: kickback 0.482 mV into 1 pF = 8.85 mV into 54.52 fF, drift 3.330 mV.
* Budget is 1.465 mV on each. ngspice is the authority, not these predictions.
.subckt cmp_uc_mim55 inp inn dout clk vdd vss nbias pbias
XINP left inp tail vdd pfet_03v3 L=0.4u W={12.4u*(1+WMIS)} nf=3 m=1
XINN outa inn tail vdd pfet_03v3 L=0.4u W=12.4u nf=3 m=1
XLOADD left left vss vss nfet_03v3 L=0.6u W=21.4u nf=5 m=1
XLOADM outa left vss vss nfet_03v3 L=0.6u W=21.4u nf=5 m=1
XTAIL tail pbias vdd vdd pfet_03v3 L=1.0u W=49.6u nf=12 m=1
COUTA outa vss 20f
XBUF1 outb outa vss vss nfet_03v3 L=0.28u W=4.0u nf=4 m=1
XBUF2 outb outa vdd vdd pfet_03v3 L=0.28u W=9.9u nf=1 m=1
XBUF3 dout outb vss vss nfet_03v3 L=0.28u W=8.0u nf=4 m=1
XBUF4 dout outb vdd vdd pfet_03v3 L=0.28u W=16.0u nf=4 m=1
.ends cmp_uc_mim55
