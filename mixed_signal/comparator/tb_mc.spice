* Trip-point spread by ngspice Monte Carlo (adapted from comparator_bkp/comparator_10dev/tb_mc.spice),
* on the PDK's mismatch model (`.param sw_stat_mismatch=1` switches on the
* agauss() draws inside every nfet_03v3 / pfet_03v3). The reference pin sits
* at VCM, the plate pin (vsw) is swept through it; each pass records where
* dout crosses VDD/2 in its decision direction (EDGE). Pass 0 is the
* mismatch-free nominal. vos = trip - VCM, in the plate's own sense (the plate
* level at which the comparator decides). XMC is the hookup (bench.py).
.include /foss/pdks/gf180mcuD/libs.tech/ngspice/design.ngspice
.lib /foss/pdks/gf180mcuD/libs.tech/ngspice/sm141064.ngspice @CORNER@
.include @DUT@
.param sw_stat_mismatch=1
.param VDD=@VDD@
.temp @TEMP@
.param IREF=@IREF@

.csparam cs_n=@NMC@

VDD_SOURCE vdd 0 {VDD}
VDD_BIAS vddb 0 {VDD}
IREFN vddb nbias {IREF}
XREFN nbias nbias 0 0 nfet_03v3 L=1u W=20u nf=10 m=1
IREFP pbias 0 {IREF}
@REFP@
VCLK clk 0 {VDD}
VREFX vrefx 0 @VCM@
VSW vsw 0 @VCM@
@XMC@
CLOAD dout 0 @CLOAD@

.control
set rndseed=@SEED@
let k = 0
alterparam sw_stat_mismatch=0
reset
dc vsw @VLO70@ @VHI70@ 0.0002
meas dc vtrip when v(dout)=@VCM@ @EDGE@=1
let vos_nom = vtrip - @VCM@
print vos_nom
alterparam sw_stat_mismatch=1
while k < $&cs_n
  reset
  dc vsw @VLO70@ @VHI70@ 0.0002
  meas dc vtrip when v(dout)=@VCM@ @EDGE@=1
  let vos_k = vtrip - @VCM@
  print vos_k
  let k = k + 1
end
quit
.endc
.end
