* Input-referred noise at the decision point (adapted from
* comparator_bkp/comparator_10dev/tb_nz.spice). dout is fed back through a 1 TH inductor to the
* pin on which it gives NEGATIVE feedback, which parks the OTA at its own trip;
* a 1 F capacitor AC-grounds that pin; the AC / noise source is the other pin,
* at VREF = VDD/2. The hookup (bench.py NZNET) per variant:
*   base  VSIG inp (DC VCM, AC 1), LFB dout -> inn, CFB inn
*   sw    VSIG inn (DC VCM, AC 1), LFB dout -> inp, CFB inp   (dout falls as inp rises)
*
*   nz_own_vin   OUTPUT noise on outa from 1 kHz to 10 GHz divided by the DC gain
*                vsig -> outa: input-referred rms over the OTA's own band,
*                thermal + 1/f (the gated number, < 1.2 mV at the pins)
*   nz_lo_vin    the same, 1 kHz .. 100 kHz (flicker part)
*   nz_ugb_vin   input-referred spectrum 1 kHz .. unity-gain frequency (bound)
.include /foss/pdks/gf180mcuD/libs.tech/ngspice/design.ngspice
.lib /foss/pdks/gf180mcuD/libs.tech/ngspice/sm141064.ngspice @CORNER@
.include @DUT@

.param VDD=@VDD@
.temp @TEMP@
.param IREF=@IREF@

.options savecurrents

VDD_SOURCE vdd 0 {VDD}
VDD_BIAS vddb 0 {VDD}
IREFN vddb nbias {IREF}
XREFN nbias nbias 0 0 nfet_03v3 L=1u W=20u nf=10 m=1
IREFP pbias 0 {IREF}
@REFP@
VCLK clk 0 {VDD}

@NZNET@
CLOAD dout 0 @CLOAD@

.control
op
let op_i_vdd = -i(vdd_source)
set s_op_i = $&op_i_vdd
ac dec 20 10 100G
meas ac ota_gain_vv find vm(xdut.outa) at=10
let g3 = ota_gain_vv / sqrt(2)
meas ac ota_pole_hz when vm(xdut.outa)=$&g3 fall=1
meas ac ota_ugbw_hz when vm(xdut.outa)=1 fall=1
set g = $&ota_gain_vv
set ugb = $&ota_ugbw_hz
set fp = $&ota_pole_hz
noise v(xdut.outa) vsig dec 20 1k 10G
let nz_own_vin = onoise_total / $g
set s_own = $&nz_own_vin
noise v(xdut.outa) vsig dec 20 1k 100k
let nz_lo_vin = onoise_total / $g
set s_lo = $&nz_lo_vin
noise v(xdut.outa) vsig dec 20 1k $ugb
let nz_ugb_vin = inoise_total
set s_ugb = $&nz_ugb_vin
echo "RESULT_BEGIN"
echo "ota_gain_vv = $g"
echo "ota_pole_hz = $fp"
echo "nz_own_vin = $s_own"
echo "nz_lo_vin = $s_lo"
echo "nz_ugb_vin = $s_ugb"
echo "op_i_vdd = $s_op_i"
echo "RESULT_END"
quit
.endc
.end
