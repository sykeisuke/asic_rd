* comparator -- continuous comparator for the TRUE BOTTOM-PLATE 8-bit cell:
* PMOS 5T OTA -> starved inverter -> output inverter (10 devices), the topology
* of ../comparator_bkp/comparator_updt_v2 re-sized on 2026-10-06 with every L <= 0.36 um for:
* delay from the static trip <= 1/4 count (12.5 ns), dout into 10 fF, noise
* at the pins (thermal + 1/f from 1 kHz, own band) < 1.2 mV. inp = VBL,
* inn = the MIM top plate; dout FALLS when inn rises through inp.
* clk and nbias are NO-CONNECTS (the cell's port list).
*
* GENERATED by size_v3.py (seed 20261006). Do not hand-edit. Recipe: DESIGN_RECIPE.md.
* Bias: pbias from an ideal 1.931 uA into one tail finger, diode-connected
* (in the benches: XREFP pbias pbias vddb vddb pfet_03v3 L=0.28u W=1u nf=1 m=1).
* Labels: [P] PDK tables (stage A), [M] ngspice (stage B, f003).
*   pair    12 x 1 um, L 0.32 um: gm/Id 14.0 S/A [P]
*   load    1 x 0.5 um, L 0.36 um: gm/Id 5.2 S/A [P]
*   tail    11 x 1 um, L 0.28 um: 19.730 uA; J_D 1.93 A/m, gm/Id 10.9 [P]
*   starve  5 x 1 um, L 0.28 um: 9.626 uA [P]
*   buffers N = XLOADM, P 1 x 1 um, L 0.36 um
*   alpha 0.761; sigma(Vos) at the ADC input 1.99 LSB [P]
*   delay from the static trip: c4 10.59 ns, plateau 10.59 ns [M]
*   noise at the pins 0.168 mV rms [M]; power 96.9 uW worst state [P]
* The simulators are the authority, not these lines.
.subckt cmp inp inn dout clk vdd vss nbias pbias
XINP left inp tail vdd pfet_03v3 L=0.32u W=12u nf=12 m=1
XINN outa inn tail vdd pfet_03v3 L=0.32u W=12u nf=12 m=1
XLOADD left left vss vss nfet_03v3 L=0.36u W=0.5u nf=1 m=1
XLOADM outa left vss vss nfet_03v3 L=0.36u W=0.5u nf=1 m=1
XTAIL tail pbias vdd vdd pfet_03v3 L=0.28u W=11u nf=11 m=1
XBST bst pbias vdd vdd pfet_03v3 L=0.28u W=5u nf=5 m=1
XBUF1 outb outa vss vss nfet_03v3 L=0.36u W=0.5u nf=1 m=1
XBUF2 outb outa bst vdd pfet_03v3 L=0.36u W=1u nf=1 m=1
XBUF3 dout outb vss vss nfet_03v3 L=0.36u W=0.5u nf=1 m=1
XBUF4 dout outb vdd vdd pfet_03v3 L=0.36u W=1u nf=1 m=1
.ends cmp
