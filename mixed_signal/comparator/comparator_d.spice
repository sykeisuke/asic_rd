* comparator_d -- the comparator: the sized core comparator_core plus one more
* output inverter: PMOS 5T OTA -> starved inverter -> inverter -> inverter
* (12 devices). Use: the floating plate on inp, VREF on inn; dout FALLS when
* inp rises through inn (the core's dout falls when inn rises through inp).
* The 10 sized devices are comparator_core.spice's, unchanged; its
* old output node is outc here. XBUF5 / XBUF6 copy XBUF3 / XBUF4.
* GENERATED by derive.py from comparator_core.spice (sha256 98f7b8bdf0a1761b...).
* Do not hand-edit.
* Macro form: the cell's bias diode XREFP inside, ports inp inn ibias dout vdd vss
.subckt comparator_d inp inn ibias dout vdd vss
XINP left inp tail vdd pfet_03v3 L=0.32u W=12u nf=12 m=1
XINN outa inn tail vdd pfet_03v3 L=0.32u W=12u nf=12 m=1
XLOADD left left vss vss nfet_03v3 L=0.36u W=0.5u nf=1 m=1
XLOADM outa left vss vss nfet_03v3 L=0.36u W=0.5u nf=1 m=1
XTAIL tail ibias vdd vdd pfet_03v3 L=0.28u W=11u nf=11 m=1
XBST bst ibias vdd vdd pfet_03v3 L=0.28u W=5u nf=5 m=1
XBUF1 outb outa vss vss nfet_03v3 L=0.36u W=0.5u nf=1 m=1
XBUF2 outb outa bst vdd pfet_03v3 L=0.36u W=1u nf=1 m=1
XBUF3 outc outb vss vss nfet_03v3 L=0.36u W=0.5u nf=1 m=1
XBUF4 outc outb vdd vdd pfet_03v3 L=0.36u W=1u nf=1 m=1
XBUF5 dout outc vss vss nfet_03v3 L=0.36u W=0.5u nf=1 m=1
XBUF6 dout outc vdd vdd pfet_03v3 L=0.36u W=1u nf=1 m=1
XREFP ibias ibias vdd vdd pfet_03v3 L=0.28u W=1u nf=1 m=1
.ends comparator_d
