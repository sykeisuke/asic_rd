* sample_seq -- the on-chip sampling sequencer of the four bottom-plate cells.
* GENERATED by size_seq.py from data/sizing.json (N = 4 delay cells per stage);
* never hand-edit. SPEC.md has the requirements, README.md the record.
*
* In: clk, the 20 MHz count clock (ADR 0024); acq, the controller's acquire
* level (1 = track). Out: per cell k the switch controls, HIGH = closed:
*   s2_k  bottom plate to vref (S2), opens first: the sampling instant
*   s0_k  input gate (S0), opens after s2_k
*   s1_k  ramp connect (S1), closes after s0_k opens, opens first on re-entry
*
* Structure (ADR 0029): a four-flop shift register on clk turns acq into one
* track level per cell, t_k, falling at the k-th rising edge after the edge
* that sees acq low (cells one period, 50 ns, apart). Each t_k drives one
* seq_clkgen: the EE628 two-phase non-overlapping clock generator
* (B. Murmann, template_clkgen.sch), cross-coupled NAND pair with the early
* phases, in the same gates, with a short delay stage D (seq_dly, N x inv_2)
* added in three of its paths so every dead time is at least the template's
* own four-inverter delay (a few hundred ps, ADR 0031):
*   p1e -> s2   phase-1 early: opens first (bottom-plate sampling)
*   p1  -> s0   phase 1: opens D later (D before b1)
*   p2e -> s1   phase-2 early: closes D after p1 opens (D after nand2),
*               opens first on re-entry, p1 closes D later (D before b2)
* The late phase 2 (p2) of the template has no switch here and is not built.
*
* Supplies: vdd / vss are the digital supply (DVDD); the cells' well pins
* are tied inside. The outputs drive atop_cell's control inputs (AVDD gates).
* Needs, before this file:
*   .include /foss/pdk_libs/gf180mcuD/libs.ref/gf180mcu_as_sc_mcu7t3v3/spice/gf180mcu_as_sc_mcu7t3v3.spice

.subckt seq_dly a y vdd vss
*.PININFO a:I y:O vdd:B vss:B
XD1 vdd vdd vss vss d1 a gf180mcu_as_sc_mcu7t3v3__inv_2
XD2 vdd vdd vss vss d2 d1 gf180mcu_as_sc_mcu7t3v3__inv_2
XD3 vdd vdd vss vss d3 d2 gf180mcu_as_sc_mcu7t3v3__inv_2
XD4 vdd vdd vss vss y d3 gf180mcu_as_sc_mcu7t3v3__inv_2
.ends seq_dly

.subckt seq_clkgen clkin p1e p1 p2e vdd vss
*.PININFO clkin:I p1e:O p1:O p2e:O vdd:B vss:B
* input buffers (inv_2: Y A)
XI1 vdd vdd vss vss clkinb clkin gf180mcu_as_sc_mcu7t3v3__inv_2
XI2 vdd vdd vss vss clkinbb clkinb gf180mcu_as_sc_mcu7t3v3__inv_2
* phase 1: nand2 (Y B A), four inverters to a1, p1e, D, b1; p1 = nand(a1, b1)
XN1 vdd vdd vss vss n1 b2 clkinbb gf180mcu_as_sc_mcu7t3v3__nand2_2
XI3 vdd vdd vss vss m1 n1 gf180mcu_as_sc_mcu7t3v3__inv_4
XI5 vdd vdd vss vss m2 m1 gf180mcu_as_sc_mcu7t3v3__inv_4
XI7 vdd vdd vss vss m3 m2 gf180mcu_as_sc_mcu7t3v3__inv_4
XI9 vdd vdd vss vss a1 m3 gf180mcu_as_sc_mcu7t3v3__inv_4
XI11 vdd vdd vss vss p1e a1 gf180mcu_as_sc_mcu7t3v3__inv_4
XL1 p1e x1 vdd vss seq_dly
XI13 vdd vdd vss vss b1 x1 gf180mcu_as_sc_mcu7t3v3__inv_4
XN3 vdd vdd vss vss y1 b1 a1 gf180mcu_as_sc_mcu7t3v3__nand2_2
XI15 vdd vdd vss vss y1b y1 gf180mcu_as_sc_mcu7t3v3__inv_4
XI17 vdd vdd vss vss p1 y1b gf180mcu_as_sc_mcu7t3v3__inv_8
* phase 2: nand2, D, four inverters to a2, p2e, D, b2
XN2 vdd vdd vss vss n2 b1 clkinb gf180mcu_as_sc_mcu7t3v3__nand2_2
XL2 n2 n2d vdd vss seq_dly
XI4 vdd vdd vss vss k1 n2d gf180mcu_as_sc_mcu7t3v3__inv_4
XI6 vdd vdd vss vss k2 k1 gf180mcu_as_sc_mcu7t3v3__inv_4
XI8 vdd vdd vss vss k3 k2 gf180mcu_as_sc_mcu7t3v3__inv_4
XI10 vdd vdd vss vss a2 k3 gf180mcu_as_sc_mcu7t3v3__inv_4
XI12 vdd vdd vss vss p2e a2 gf180mcu_as_sc_mcu7t3v3__inv_4
XL3 p2e x2 vdd vss seq_dly
XI14 vdd vdd vss vss b2 x2 gf180mcu_as_sc_mcu7t3v3__inv_4
.ends seq_clkgen

.subckt sample_seq acq clk s2_0 s2_1 s2_2 s2_3 s0_0 s0_1 s0_2 s0_3 s1_0 s1_1 s1_2 s1_3 vdd vss
*.PININFO acq:I clk:I s2_0:O s2_1:O s2_2:O s2_3:O s0_0:O s0_1:O s0_2:O s0_3:O s1_0:O s1_1:O s1_2:O s1_3:O vdd:B vss:B
* shift register (dfxtp_2: CLK D Q): t_k = track level of cell k
XF0 vdd vdd vss vss clk acq t0 gf180mcu_as_sc_mcu7t3v3__dfxtp_2
XF1 vdd vdd vss vss clk t0 t1 gf180mcu_as_sc_mcu7t3v3__dfxtp_2
XF2 vdd vdd vss vss clk t1 t2 gf180mcu_as_sc_mcu7t3v3__dfxtp_2
XF3 vdd vdd vss vss clk t2 t3 gf180mcu_as_sc_mcu7t3v3__dfxtp_2
* one EE628 clock generator per cell
XG0 t0 s2_0 s0_0 s1_0 vdd vss seq_clkgen
XG1 t1 s2_1 s0_1 s1_1 vdd vss seq_clkgen
XG2 t2 s2_2 s0_2 s1_2 vdd vss seq_clkgen
XG3 t3 s2_3 s0_3 s1_3 vdd vss seq_clkgen
.ends sample_seq
