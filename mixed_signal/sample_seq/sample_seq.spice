* sample_seq -- the on-chip sampling sequencer of the four bottom-plate cells.
* GENERATED by size_seq.py from data/sizing.json (N = 22 delay cells per stage);
* never hand-edit. SPEC.md has the requirements, README.md the record.
*
* In: clk, the 20 MHz count clock (ADR 0024); acq, the controller's acquire
* level (1 = track). Out: per cell k the switch controls, HIGH = closed:
*   s2_k  bottom plate to vref (S2), opens first: the sampling instant
*   s0_k  input gate (S0), opens one stage delay D after s2_k
*   s1_k  ramp connect (S1), closes one stage delay D after s0_k
* Cell k samples at the k-th clock rising edge after the edge that sees acq
* low: the S2 flops form the token chain, cells one period (50 ns) apart.
*
* Timing: one tapped delay line, shared by the four cells:
*   c0 = gated clk, buffered; c5 = c0 + D; c10 = c5 + D  (D = 22 x dlybuff_2)
* Per cell three rising-edge flops in a pipeline, each sampling the previous
* phase's state, so a phase can move only after the one before it has moved
* (the lock-out of a cross-coupled non-overlap generator, here without its
* dependence on the clock's falling edge):
*   qa = s2 <- tin at c0      (tin = acq for cell 0, s2 of the cell before)
*   qb = s0 <- qa  at c5
*   qc      <- qb  at c10,    s1 = NOR(qc, qa)
* Entry: s2 falls, s0 falls D later, s1 rises D later. Re-entry (acq high):
* s1 falls with s2's rise, s0 rises D later (S1 open before S0 closes).
*
* Supplies: vdd / vss are the digital supply (DVDD); the cells' well pins
* are tied inside. The outputs drive atop_cell's control inputs (AVDD gates).
* Needs, before this file:
*   .include /foss/pdk_libs/gf180mcuD/libs.ref/gf180mcu_as_sc_mcu7t3v3/spice/gf180mcu_as_sc_mcu7t3v3.spice

.subckt seq_dly a y vdd vss
*.PININFO a:I y:O vdd:B vss:B
XD1 vdd vdd vss vss d1 a gf180mcu_as_sc_mcu7t3v3__dlybuff_2
XD2 vdd vdd vss vss d2 d1 gf180mcu_as_sc_mcu7t3v3__dlybuff_2
XD3 vdd vdd vss vss d3 d2 gf180mcu_as_sc_mcu7t3v3__dlybuff_2
XD4 vdd vdd vss vss d4 d3 gf180mcu_as_sc_mcu7t3v3__dlybuff_2
XD5 vdd vdd vss vss d5 d4 gf180mcu_as_sc_mcu7t3v3__dlybuff_2
XD6 vdd vdd vss vss d6 d5 gf180mcu_as_sc_mcu7t3v3__dlybuff_2
XD7 vdd vdd vss vss d7 d6 gf180mcu_as_sc_mcu7t3v3__dlybuff_2
XD8 vdd vdd vss vss d8 d7 gf180mcu_as_sc_mcu7t3v3__dlybuff_2
XD9 vdd vdd vss vss d9 d8 gf180mcu_as_sc_mcu7t3v3__dlybuff_2
XD10 vdd vdd vss vss d10 d9 gf180mcu_as_sc_mcu7t3v3__dlybuff_2
XD11 vdd vdd vss vss d11 d10 gf180mcu_as_sc_mcu7t3v3__dlybuff_2
XD12 vdd vdd vss vss d12 d11 gf180mcu_as_sc_mcu7t3v3__dlybuff_2
XD13 vdd vdd vss vss d13 d12 gf180mcu_as_sc_mcu7t3v3__dlybuff_2
XD14 vdd vdd vss vss d14 d13 gf180mcu_as_sc_mcu7t3v3__dlybuff_2
XD15 vdd vdd vss vss d15 d14 gf180mcu_as_sc_mcu7t3v3__dlybuff_2
XD16 vdd vdd vss vss d16 d15 gf180mcu_as_sc_mcu7t3v3__dlybuff_2
XD17 vdd vdd vss vss d17 d16 gf180mcu_as_sc_mcu7t3v3__dlybuff_2
XD18 vdd vdd vss vss d18 d17 gf180mcu_as_sc_mcu7t3v3__dlybuff_2
XD19 vdd vdd vss vss d19 d18 gf180mcu_as_sc_mcu7t3v3__dlybuff_2
XD20 vdd vdd vss vss d20 d19 gf180mcu_as_sc_mcu7t3v3__dlybuff_2
XD21 vdd vdd vss vss d21 d20 gf180mcu_as_sc_mcu7t3v3__dlybuff_2
XD22 vdd vdd vss vss y d21 gf180mcu_as_sc_mcu7t3v3__dlybuff_2
.ends seq_dly

.subckt seq_cell tin c0 c5 c10 s2 s0 s1 done vdd vss
*.PININFO tin:I c0:I c5:I c10:I s2:O s0:O s1:O done:O vdd:B vss:B
XFA vdd vdd vss vss c0 tin s2 gf180mcu_as_sc_mcu7t3v3__dfxtp_2
XFB vdd vdd vss vss c5 s2 s0 gf180mcu_as_sc_mcu7t3v3__dfxtp_2
XFC vdd vdd vss vss c10 s0 qc gf180mcu_as_sc_mcu7t3v3__dfxtp_2
XNR vdd vdd vss vss s1 qc s2 gf180mcu_as_sc_mcu7t3v3__nor2_2
* done = the three flops agree with tin (nothing left to move in this cell)
XX1 vdd vdd vss vss s2 tin x1 gf180mcu_as_sc_mcu7t3v3__xor2_2
XX2 vdd vdd vss vss s0 s2 x2 gf180mcu_as_sc_mcu7t3v3__xor2_2
XX3 vdd vdd vss vss qc s0 x3 gf180mcu_as_sc_mcu7t3v3__xor2_2
XND vdd vdd vss vss x1 x2 x3 done gf180mcu_as_sc_mcu7t3v3__nor3_2
.ends seq_cell

.subckt sample_seq acq clk s2_0 s2_1 s2_2 s2_3 s0_0 s0_1 s0_2 s0_3 s1_0 s1_1 s1_2 s1_3 vdd vss
*.PININFO acq:I clk:I s2_0:O s2_1:O s2_2:O s2_3:O s0_0:O s0_1:O s0_2:O s0_3:O s1_0:O s1_1:O s1_2:O s1_3:O vdd:B vss:B
* clock gate: the line runs only while a cell has something to move (en =
* NOT all done), so it is quiet through the conversion; en is latched while
* clk is low (dlxtn_2 is transparent for ENA = 0), gclk = clk AND en_l
XEN vdd vdd vss vss done_0 done_1 done_2 done_3 en gf180mcu_as_sc_mcu7t3v3__nand4_2
XLG vdd vdd vss vss clk en en_l gf180mcu_as_sc_mcu7t3v3__dlxtn_2
XAG vdd vdd vss vss en_l clk gclk gf180mcu_as_sc_mcu7t3v3__and2_2
XB0 vdd vdd vss vss gclk c0 gf180mcu_as_sc_mcu7t3v3__clkbuff_4
XL1 c0 c5r vdd vss seq_dly
XB5 vdd vdd vss vss c5r c5 gf180mcu_as_sc_mcu7t3v3__clkbuff_4
XL2 c5 c10r vdd vss seq_dly
XB10 vdd vdd vss vss c10r c10 gf180mcu_as_sc_mcu7t3v3__clkbuff_4
XC0 acq c0 c5 c10 s2_0 s0_0 s1_0 done_0 vdd vss seq_cell
XC1 s2_0 c0 c5 c10 s2_1 s0_1 s1_1 done_1 vdd vss seq_cell
XC2 s2_1 c0 c5 c10 s2_2 s0_2 s1_2 done_2 vdd vss seq_cell
XC3 s2_2 c0 c5 c10 s2_3 s0_3 s1_3 done_3 vdd vss seq_cell
.ends sample_seq
