* midref_v2 -- FVF class-AB VDD/2 buffer (VREF / VBL of the 8-bit bottom-plate cell),
* the topology of ../midrail_ref_bkp/midrail_ref re-sized 2026-10-07 with every L in 0.28..0.36 um,
* one finger width per flavour, gm/Id-sampled whole fingers, divider + tap + output
* capacitor in the search, power x area knee. GENERATED by size_v2.py; do not hand-edit.
* Bias: an IDEAL current into port ib (one NMOS diode finger, XMBN).
*   i_f 12.36 uA, IB = 1 fingers, output ratio K 1
*   area 340 um2 per buffer (MOS 102.8, poly 91, MIM 147; a shared divider counted half) [P]
*   power 247.0 uW per buffer at typical/27 C/3.3 V, the shared tap counted half [M]; VREF + VBL noise 0.0386 LSB [M]
*   divider shared by VREF and VBL (use midref_div + midref_buf)
* Ports: midref_div (vin vdd vss); midref_buf (out vin ib vdd vss); midref2 (out ib vdd vss).
* The simulators are the authority, not these lines.

.subckt midref_div vin vdd vss
XRT vdd vin vss ppolyf_u_3k r_width=1u r_length=64.98u
XRB vin vss vss ppolyf_u_3k r_width=1u r_length=64.98u
XCT vin vss cap_mim_2f0_m4m5_noshield c_width=4.423u c_length=4.423u
.ends midref_div

.subckt midref_buf out vin ib vdd vss
XMBN ib ib vss vss nfet_03v3 L=0.34u W=0.5u nf=1 m=1
XMBN2 pb ib vss vss nfet_03v3 L=0.34u W=0.5u nf=1 m=1
XMBP pb pb vdd vdd pfet_03v3 L=0.34u W=2u nf=1 m=1
XMIT a pb vdd vdd pfet_03v3 L=0.34u W=2u nf=1 m=1
XMIB b ib vss vss nfet_03v3 L=0.34u W=0.5u nf=1 m=1
XM3 p b vdd vdd pfet_03v3 L=0.36u W=2u nf=1 m=1
XM1 b vin p vdd pfet_03v3 L=0.34u W=40u nf=20 m=1
XM2 out out p vdd pfet_03v3 L=0.34u W=40u nf=20 m=1
XM6 n a vss vss nfet_03v3 L=0.36u W=0.5u nf=1 m=1
XM4 a vin n vss nfet_03v3 L=0.34u W=13u nf=26 m=1
XM5 out out n vss nfet_03v3 L=0.34u W=13u nf=26 m=1
XCD out vss cap_mim_2f0_m4m5_noshield c_width=11.7u c_length=11.7u
.ends midref_buf

.subckt midref2 out ib vdd vss
XD vin vdd vss midref_div
XB out vin ib vdd vss midref_buf
.ends midref2
