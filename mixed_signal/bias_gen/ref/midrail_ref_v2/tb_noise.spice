* Output noise of one buffer (typical, 27 C, 3.3 V), 10 Hz - 1 GHz, the band
* of the noise budget's reference bound (../Analog_top_bkp/unit_cell_noise/NOISE_BUDGET.md
* s.4.6). TEMPLATE: if. Writes three spectra for size_v2.py, which splits the
* divider's share out (it is common to both buffers when they share one tap):
*   nz_out.txt  onoise at out (V/rtHz)
*   nz_tap.txt  onoise at the tap vin (V/rtHz): the divider's own noise
*   ac.txt      |v(out)| and |v(vin)| for a current injected at the tap, so
*               |out/vin| is the tap-to-output transfer
.include /foss/pdks/gf180mcuD/libs.tech/ngspice/design.ngspice
.lib /foss/pdks/gf180mcuD/libs.tech/ngspice/sm141064.ngspice typical
.lib /foss/pdks/gf180mcuD/libs.tech/ngspice/sm141064.ngspice res_typical
.lib /foss/pdks/gf180mcuD/libs.tech/ngspice/sm141064.ngspice mimcap_typical
.include dut.spice

VDD_SOURCE vdd 0 3.3
IREF vdd ib @IF@
XD vin vdd 0 midref_div
XB out vin ib vdd 0 midref_buf
IINJ 0 vin DC 0 AC 1
* the noise analysis' nominal input: a dummy, isolated from the circuit
VNIN nin 0 DC 0 AC 1
RNIN nin 0 1g

.control
set num_threads=1
set wr_singlescale
noise v(out) VNIN dec 20 10 1g
setplot noise1
wrdata nz_out.txt onoise_spectrum
setplot const
noise v(vin) VNIN dec 20 10 1g
setplot noise3
wrdata nz_tap.txt onoise_spectrum
setplot const
ac dec 20 10 1g
wrdata ac.txt vm(out) vm(vin)
quit
.endc
.end
