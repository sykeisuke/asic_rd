* bias_gen -- constant-gm (beta-multiplier) bias generator for the 8-bit
* bottom-plate ADC: current outputs to four comparator comparators, the ramp
* and the two midref_v2 buffers. GENERATED by size_bg.py; do not hand-edit.
* Every MOS: one L and one finger width, PMOS row over NMOS row (floorplan.py).
*   L 0.9 um, finger W 4 um, K 8, R 5 x 10.732 um ppolyf_u (W 1 um)
*   core 3.577 uA per branch, XMN1 gm/Id 21.9, PMOS mirror gm/Id 18.6 [P]
*   cmp sink 8 fingers: 1.681 x 1.931 uA [M]; ramp sink 8 fingers: 3.257 uA [M];
*   midref source 44 fingers: 0.868 x 12.36 uA [M]
*   135-cell requirement s_pvt 1.471 [M] x (1 + 3 sigma 4.76 % [P])
*   decaps: pb 1 pF to vdd, nb 1 pF to vss (MIM over the rows)
* Ports: vdd vss icmp0..3 (sinks, to each comparator's own pbias diode), iramp (sink,
* to the ramp's L=1u W=20u nf=10 diode), ivref ivbl (sources, to midref_buf ib).
* The simulators are the authority, not these lines.
.subckt bias_gen vdd vss icmp0 icmp1 icmp2 icmp3 iramp ivref ivbl
* ---- core: NMOS-defined beta multiplier
XMN1 nb nb vss vss nfet_03v3 L=0.9u W=40u nf=10 m=1 ad=3.6p pd=41.8u as=4.32p ps=50.16u nrd=0.0045 nrs=0.0045
XMN2 pb nb ns vss nfet_03v3 L=0.9u W=80u nf=20 m=4 ad=7.2p pd=83.6u as=7.92p ps=91.96u nrd=0.00225 nrs=0.00225
XMP1 nb pb vdd vdd pfet_03v3 L=0.9u W=56u nf=14 m=1 ad=5.04p pd=58.52u as=5.76p ps=66.88u nrd=0.003214 nrs=0.003214
XMP2 pb pb vdd vdd pfet_03v3 L=0.9u W=56u nf=14 m=1 ad=5.04p pd=58.52u as=5.76p ps=66.88u nrd=0.003214 nrs=0.003214
XR1 ns r1 vss ppolyf_u r_width=1u r_length=10.7324u
XR2 r1 r2 vss ppolyf_u r_width=1u r_length=10.7324u
XR3 r2 r3 vss ppolyf_u r_width=1u r_length=10.7324u
XR4 r3 r4 vss ppolyf_u r_width=1u r_length=10.7324u
XR5 r4 vss vss ppolyf_u r_width=1u r_length=10.7324u
* ---- output sinks (gate nb) and sources (gate pb)
XOC0 icmp0 nb vss vss nfet_03v3 L=0.9u W=32u nf=8 m=1 ad=2.88p pd=33.44u as=3.6p ps=41.8u nrd=0.005625 nrs=0.005625
XOC1 icmp1 nb vss vss nfet_03v3 L=0.9u W=32u nf=8 m=1 ad=2.88p pd=33.44u as=3.6p ps=41.8u nrd=0.005625 nrs=0.005625
XOC2 icmp2 nb vss vss nfet_03v3 L=0.9u W=32u nf=8 m=1 ad=2.88p pd=33.44u as=3.6p ps=41.8u nrd=0.005625 nrs=0.005625
XOC3 icmp3 nb vss vss nfet_03v3 L=0.9u W=32u nf=8 m=1 ad=2.88p pd=33.44u as=3.6p ps=41.8u nrd=0.005625 nrs=0.005625
XOR iramp nb vss vss nfet_03v3 L=0.9u W=32u nf=8 m=1 ad=2.88p pd=33.44u as=3.6p ps=41.8u nrd=0.005625 nrs=0.005625
XOV ivref pb vdd vdd pfet_03v3 L=0.9u W=88u nf=22 m=2 ad=7.92p pd=91.96u as=8.64p ps=100.3u nrd=0.002045 nrs=0.002045
XOB ivbl pb vdd vdd pfet_03v3 L=0.9u W=88u nf=22 m=2 ad=7.92p pd=91.96u as=8.64p ps=100.3u nrd=0.002045 nrs=0.002045
* ---- startup: bleeder of PMOS diodes, disengage, kick
XSB1 sb1 sb1 vdd vdd pfet_03v3 L=0.9u W=4u nf=1 m=1 ad=0.72p pd=8.36u as=0.72p ps=8.36u nrd=0.045 nrs=0.045
XSB2 sb2 sb2 sb1 vdd pfet_03v3 L=0.9u W=4u nf=1 m=1 ad=0.72p pd=8.36u as=0.72p ps=8.36u nrd=0.045 nrs=0.045
XSB3 sb3 sb3 sb2 vdd pfet_03v3 L=0.9u W=4u nf=1 m=1 ad=0.72p pd=8.36u as=0.72p ps=8.36u nrd=0.045 nrs=0.045
XSB4 su su sb3 vdd pfet_03v3 L=0.9u W=4u nf=1 m=1 ad=0.72p pd=8.36u as=0.72p ps=8.36u nrd=0.045 nrs=0.045
XSU4 su nb vss vss nfet_03v3 L=0.9u W=4u nf=1 m=1 ad=0.72p pd=8.36u as=0.72p ps=8.36u nrd=0.045 nrs=0.045
XSU5 pb su vss vss nfet_03v3 L=0.9u W=4u nf=1 m=1 ad=0.72p pd=8.36u as=0.72p ps=8.36u nrd=0.045 nrs=0.045
* ---- decoupling (MIM over the rows)
XCP vdd pb cap_mim_2f0_m4m5_noshield c_width=22.3607u c_length=22.3607u
XCN nb vss cap_mim_2f0_m4m5_noshield c_width=22.3607u c_length=22.3607u
.ends bias_gen
