* vrlo_ref -- VR_LO shunt regulator (0.5 V = 5/33 AVDD) for ramp_simple's reset switch.
* GENERATED by size_vrlo.py; do not hand-edit. Ports: vrlo ib avdd avss.
* Bias: an IDEAL current IB = 1.37 uA into ib (one NMOS diode finger, XMBN).
* power 38.8 uW (typical, 27 C, 3.3 V, reset state, incl. IB) [M]; area 2942 um2 (MOS 58, poly 660, MIM 2224) [P]
* The simulators are the authority, not these lines.

.subckt vrlo_ref vrlo ib avdd avss
XR1 avdd r1 avss ppolyf_u_3k r_width=1u r_length=20u
XR2 r1 r2 avss ppolyf_u_3k r_width=1u r_length=20u
XR3 r2 r3 avss ppolyf_u_3k r_width=1u r_length=20u
XR4 r3 r4 avss ppolyf_u_3k r_width=1u r_length=20u
XR5 r4 r5 avss ppolyf_u_3k r_width=1u r_length=20u
XR6 r5 r6 avss ppolyf_u_3k r_width=1u r_length=20u
XR7 r6 r7 avss ppolyf_u_3k r_width=1u r_length=20u
XR8 r7 r8 avss ppolyf_u_3k r_width=1u r_length=20u
XR9 r8 r9 avss ppolyf_u_3k r_width=1u r_length=20u
XR10 r9 r10 avss ppolyf_u_3k r_width=1u r_length=20u
XR11 r10 r11 avss ppolyf_u_3k r_width=1u r_length=20u
XR12 r11 r12 avss ppolyf_u_3k r_width=1u r_length=20u
XR13 r12 r13 avss ppolyf_u_3k r_width=1u r_length=20u
XR14 r13 r14 avss ppolyf_u_3k r_width=1u r_length=20u
XR15 r14 r15 avss ppolyf_u_3k r_width=1u r_length=20u
XR16 r15 r16 avss ppolyf_u_3k r_width=1u r_length=20u
XR17 r16 r17 avss ppolyf_u_3k r_width=1u r_length=20u
XR18 r17 r18 avss ppolyf_u_3k r_width=1u r_length=20u
XR19 r18 r19 avss ppolyf_u_3k r_width=1u r_length=20u
XR20 r19 r20 avss ppolyf_u_3k r_width=1u r_length=20u
XR21 r20 r21 avss ppolyf_u_3k r_width=1u r_length=20u
XR22 r21 r22 avss ppolyf_u_3k r_width=1u r_length=20u
XR23 r22 r23 avss ppolyf_u_3k r_width=1u r_length=20u
XR24 r23 r24 avss ppolyf_u_3k r_width=1u r_length=20u
XR25 r24 r25 avss ppolyf_u_3k r_width=1u r_length=20u
XR26 r25 r26 avss ppolyf_u_3k r_width=1u r_length=20u
XR27 r26 r27 avss ppolyf_u_3k r_width=1u r_length=20u
XR28 r27 tap avss ppolyf_u_3k r_width=1u r_length=20u
XR29 tap r29 avss ppolyf_u_3k r_width=1u r_length=20u
XR30 r29 r30 avss ppolyf_u_3k r_width=1u r_length=20u
XR31 r30 r31 avss ppolyf_u_3k r_width=1u r_length=20u
XR32 r31 r32 avss ppolyf_u_3k r_width=1u r_length=20u
XR33 r32 avss avss ppolyf_u_3k r_width=1u r_length=20u
XCT tap avss cap_mim_2f0_m4m5_noshield c_width=22.4u c_length=22.4u
XMBN ib ib avss avss nfet_03v3 L=1u W=1u nf=1 m=1
XMBN2 pb ib avss avss nfet_03v3 L=1u W=1u nf=1 m=1
XMBP pb pb avdd avdd pfet_03v3 L=1u W=2u nf=1 m=1
XMT ts pb avdd avdd pfet_03v3 L=1u W=4u nf=2 m=1
XMK vrlo pb avdd avdd pfet_03v3 L=1u W=6u nf=3 m=1
XM1 d1 vrlo ts avdd pfet_03v3 L=0.5u W=14u nf=7 m=1
XM2 g tap ts avdd pfet_03v3 L=0.5u W=14u nf=7 m=1
XM3 d1 d1 avss avss nfet_03v3 L=1u W=6u nf=6 m=1
XM4 g d1 avss avss nfet_03v3 L=1u W=4u nf=4 m=1
XM5 g g avss avss nfet_03v3 L=1u W=2u nf=2 m=1
XMS vrlo g avss avss nfet_03v3 L=1u W=18u nf=18 m=1
XCD vrlo avss cap_mim_2f0_m4m5_noshield c_width=41.5u c_length=41.5u
.ends vrlo_ref
