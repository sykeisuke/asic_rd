* analog_top -- the analog macro of the 8-bit true bottom-plate single-slope ADC:
* four sampling/conversion cells on one shared ramp_simple, bias_gen, one
* midref_div and two midref_buf.
*
* GENERATED from analog_top.sch by schematic.sh (xschem, hierarchical: every
* block down to transistors, as drawn). DO NOT HAND-EDIT. Change the drawings
* (analog_top_sch.py, the blocks' own .sch) and rewrite this file with
*   ./scripts/sim.sh analog-top PHASES=schematic REGEN=1
* Without REGEN the schematic phase FAILs while this file differs from what
* the drawings netlist to.
*
* Subcircuits: analog_top, atop_cell, bias_gen, midref_div, midref_buf,
* ramp_simple, comparator, tspc_dff, sw_s0, sw_s1, sw_s2. comparator,
* tspc_dff and sw_s0/1/2 carry drawn S/D junction geometry (the PDK MOS
* symbols' ad/as/pd/ps/nrd/nrs; the switches' from their deck).
* No model or parameter card: the including deck carries the PDK models
* (typical / res_typical / mimcap_typical) and
* ../ramp_gen/data/ramp_simple_params.spice ({RS_*}).
* The hand-written contract this replaced (2026-10-08) is kept unchanged in
* trannoise/ref_decks/analog_top.spice.
*
** sch_path: /foss/designs/mixed_signal/vrlo_ref/macro/ref_analog_top/analog_top.sch
.subckt analog_top vin vrlo ramp_rst cnt_clk s0_0 s0_1 s0_2 s0_3 s1_0 s1_1 s1_2 s1_3 s2_0 s2_1 s2_2 s2_3 q0 q1 q2 q3 avdd avss
+ dvdd dvss
*.PININFO vin:I vrlo:I ramp_rst:I cnt_clk:I s0_0:I s0_1:I s0_2:I s0_3:I s1_0:I s1_1:I s1_2:I s1_3:I s2_0:I s2_1:I s2_2:I s2_3:I
*+ q0:O q1:O q2:O q3:O avdd:B avss:B dvdd:B dvss:B
VMBG avdd avdd_bg 0
VMREF avdd avdd_ref 0
VMRAMP avdd avdd_ramp 0
VMC0 avdd avdd_c0 0
VMC1 avdd avdd_c1 0
VMC2 avdd avdd_c2 0
VMC3 avdd avdd_c3 0
XBG avdd_bg avss pbias0 pbias1 pbias2 pbias3 pbias_r ivref ivbl bias_gen
XDIV vmid avdd_ref avss midref_div
XVREF vref vmid ivref avdd_ref avss midref_buf
XVBL vbl vmid ivbl avdd_ref avss midref_buf
XRD pbias_r pbias_r avdd_ramp avdd_ramp pfet_03v3 L=1u W=20u nf=10
XRAMP vramp ramp_rst vrlo pbias_r avdd_ramp avss ramp_simple
XC0 vin vramp s0_0 s1_0 s2_0 vref vbl pbias0 q0 cnt_clk avdd_c0 avss dvdd dvss atop_cell
XC1 vin vramp s0_1 s1_1 s2_1 vref vbl pbias1 q1 cnt_clk avdd_c1 avss dvdd dvss atop_cell
XC2 vin vramp s0_2 s1_2 s2_2 vref vbl pbias2 q2 cnt_clk avdd_c2 avss dvdd dvss atop_cell
XC3 vin vramp s0_3 s1_3 s2_3 vref vbl pbias3 q3 cnt_clk avdd_c3 avss dvdd dvss atop_cell
.ends

* expanding   symbol:  bias_gen.sym # of pins=9
** sym_path: /foss/designs/mixed_signal/bias_gen/bias_gen.sym
** sch_path: /foss/designs/mixed_signal/bias_gen/bias_gen.sch
.subckt bias_gen vdd vss icmp0 icmp1 icmp2 icmp3 iramp ivref ivbl
*.PININFO vdd:B vss:B icmp0:B icmp1:B icmp2:B icmp3:B iramp:B ivref:B ivbl:B
XSB1 sb1 sb1 vdd vdd pfet_03v3 L=0.9u W=4u nf=1 m=1 ad=0.72p pd=8.36u as=0.72p ps=8.36u nrd=0.045 nrs=0.045
XSB2 sb2 sb2 sb1 vdd pfet_03v3 L=0.9u W=4u nf=1 m=1 ad=0.72p pd=8.36u as=0.72p ps=8.36u nrd=0.045 nrs=0.045
XSB3 sb3 sb3 sb2 vdd pfet_03v3 L=0.9u W=4u nf=1 m=1 ad=0.72p pd=8.36u as=0.72p ps=8.36u nrd=0.045 nrs=0.045
XSB4 su su sb3 vdd pfet_03v3 L=0.9u W=4u nf=1 m=1 ad=0.72p pd=8.36u as=0.72p ps=8.36u nrd=0.045 nrs=0.045
XSU4 su nb vss vss nfet_03v3 L=0.9u W=4u nf=1 m=1 ad=0.72p pd=8.36u as=0.72p ps=8.36u nrd=0.045 nrs=0.045
XSU5 pb su vss vss nfet_03v3 L=0.9u W=4u nf=1 m=1 ad=0.72p pd=8.36u as=0.72p ps=8.36u nrd=0.045 nrs=0.045
XMP1 nb pb vdd vdd pfet_03v3 L=0.9u W=56u nf=14 m=1 ad=5.04p pd=58.52u as=5.76p ps=66.88u nrd=0.003214 nrs=0.003214
XMP2 pb pb vdd vdd pfet_03v3 L=0.9u W=56u nf=14 m=1 ad=5.04p pd=58.52u as=5.76p ps=66.88u nrd=0.003214 nrs=0.003214
XMN1 nb nb vss vss nfet_03v3 L=0.9u W=40u nf=10 m=1 ad=3.6p pd=41.8u as=4.32p ps=50.16u nrd=0.0045 nrs=0.0045
XMN2 pb nb ns vss nfet_03v3 L=0.9u W=80u nf=20 m=4 ad=7.2p pd=83.6u as=7.92p ps=91.96u nrd=0.00225 nrs=0.00225
XR1 ns r1 vss ppolyf_u r_width=1u r_length=10.7324u
XR2 r1 r2 vss ppolyf_u r_width=1u r_length=10.7324u
XR3 r2 r3 vss ppolyf_u r_width=1u r_length=10.7324u
XR4 r3 r4 vss ppolyf_u r_width=1u r_length=10.7324u
XR5 r4 vss vss ppolyf_u r_width=1u r_length=10.7324u
XCP vdd pb cap_mim_2f0_m4m5_noshield c_width=22.3607u c_length=22.3607u
XCN nb vss cap_mim_2f0_m4m5_noshield c_width=22.3607u c_length=22.3607u
XOC0 icmp0 nb vss vss nfet_03v3 L=0.9u W=32u nf=8 m=1 ad=2.88p pd=33.44u as=3.6p ps=41.8u nrd=0.005625 nrs=0.005625
XOC1 icmp1 nb vss vss nfet_03v3 L=0.9u W=32u nf=8 m=1 ad=2.88p pd=33.44u as=3.6p ps=41.8u nrd=0.005625 nrs=0.005625
XOC2 icmp2 nb vss vss nfet_03v3 L=0.9u W=32u nf=8 m=1 ad=2.88p pd=33.44u as=3.6p ps=41.8u nrd=0.005625 nrs=0.005625
XOC3 icmp3 nb vss vss nfet_03v3 L=0.9u W=32u nf=8 m=1 ad=2.88p pd=33.44u as=3.6p ps=41.8u nrd=0.005625 nrs=0.005625
XOR iramp nb vss vss nfet_03v3 L=0.9u W=32u nf=8 m=1 ad=2.88p pd=33.44u as=3.6p ps=41.8u nrd=0.005625 nrs=0.005625
XOV ivref pb vdd vdd pfet_03v3 L=0.9u W=88u nf=22 m=2 ad=7.92p pd=91.96u as=8.64p ps=100.3u nrd=0.002045 nrs=0.002045
XOB ivbl pb vdd vdd pfet_03v3 L=0.9u W=88u nf=22 m=2 ad=7.92p pd=91.96u as=8.64p ps=100.3u nrd=0.002045 nrs=0.002045
.ends

* expanding   symbol:  midref_div.sym # of pins=3
** sym_path: /foss/designs/mixed_signal/midrail_ref_bkp/midrail_ref_v2/midref_div.sym
** sch_path: /foss/designs/mixed_signal/midrail_ref_bkp/midrail_ref_v2/midref_div.sch
.subckt midref_div vin vdd vss
*.PININFO vdd:B vss:B vin:O
XRT vdd vin vss ppolyf_u_3k r_width=1u r_length=64.98u
XRB vin vss vss ppolyf_u_3k r_width=1u r_length=64.98u
XCT vin vss cap_mim_2f0_m4m5_noshield c_width=4.423u c_length=4.423u
.ends

* expanding   symbol:  midref_buf.sym # of pins=5
** sym_path: /foss/designs/mixed_signal/midrail_ref_bkp/midrail_ref_v2/midref_buf.sym
** sch_path: /foss/designs/mixed_signal/midrail_ref_bkp/midrail_ref_v2/midref_buf.sch
.subckt midref_buf out vin ib vdd vss
*.PININFO vdd:B vss:B ib:I vin:I out:O
XMBN ib ib vss vss nfet_03v3 L=0.34u W=0.5u nf=1
XMBN2 pb ib vss vss nfet_03v3 L=0.34u W=0.5u nf=1
XMBP pb pb vdd vdd pfet_03v3 L=0.34u W=2u nf=1
XM1 b vin p vdd pfet_03v3 L=0.34u W=40u nf=20
XMIB b ib vss vss nfet_03v3 L=0.34u W=0.5u nf=1
XMIT a pb vdd vdd pfet_03v3 L=0.34u W=2u nf=1
XM4 a vin n vss nfet_03v3 L=0.34u W=13u nf=26
XM3 p b vdd vdd pfet_03v3 L=0.36u W=2u nf=1
XM2 out out p vdd pfet_03v3 L=0.34u W=40u nf=20
XM5 out out n vss nfet_03v3 L=0.34u W=13u nf=26
XM6 n a vss vss nfet_03v3 L=0.36u W=0.5u nf=1
XCD out vss cap_mim_2f0_m4m5_noshield c_width=11.7u c_length=11.7u
.ends

* expanding   symbol:  ramp_simple.sym # of pins=6
** sym_path: /foss/designs/mixed_signal/ramp_gen/ramp_simple.sym
** sch_path: /foss/designs/mixed_signal/ramp_gen/ramp_simple.sch
.subckt ramp_simple vramp rst vrlo pbias vdd vss
*.PININFO vramp:O rst:I vrlo:I pbias:I vdd:B vss:B
XPS vramp pbias vdd vdd pfet_03v3 L={RS_LPS} W={RS_WPS} nf={RS_NFPS}
XCR vramp vss cap_mim_2f0_m4m5_noshield c_width={RS_CW} c_length={RS_CW}
XRST vramp rst vrlo vss nfet_03v3 L=0.28u W={RS_WRST} nf=1
.ends

* expanding   symbol:  atop_cell.sym # of pins=14
** sym_path: /foss/designs/mixed_signal/vrlo_ref/macro/ref_analog_top/atop_cell.sym
** sch_path: /foss/designs/mixed_signal/vrlo_ref/macro/ref_analog_top/atop_cell.sch
.subckt atop_cell vfe vramp s0 s1 s2 vref vbl pbias q clk vdd vss dvdd dvss
*.PININFO vfe:I vramp:I s0:I s1:I s2:I vref:I vbl:I pbias:I q:O clk:I vdd:B vss:B dvdd:B dvss:B
XI0P s0b s0 vdd vdd pfet_03v3 L=0.28u W=0.88u nf=1
XI0N s0b s0 vss vss nfet_03v3 L=0.28u W=0.44u nf=1
XI1P s1b s1 vdd vdd pfet_03v3 L=0.28u W=0.88u nf=1
XI1N s1b s1 vss vss nfet_03v3 L=0.28u W=0.44u nf=1
XI2P s2b s2 vdd vdd pfet_03v3 L=0.28u W=0.88u nf=1
XI2N s2b s2 vss vss nfet_03v3 L=0.28u W=0.44u nf=1
XS2 vref top s2 s2b vdd vss sw_s2
XS0 vfe bot s0 s0b vdd vss sw_s0
XS1 vramp bot s1 s1b vdd vss sw_s1
XCS top bot cap_mim_2f0_m4m5_noshield c_width=5u c_length=5u
RLKT top vss 1e15
RLKB bot vss 1e15
XCMP vbl top dout vss vdd vss vss pbias comparator
XREFP pbias pbias vdd vdd pfet_03v3 L=0.28u W=1u nf=1
XFF dout clk q dvdd dvss tspc_dff
.ends

* expanding   symbol:  sw_s2.sym # of pins=6
** sym_path: /foss/designs/mixed_signal/vrlo_ref/macro/ref_analog_top/sw_s2.sym
** sch_path: /foss/designs/mixed_signal/vrlo_ref/macro/ref_analog_top/sw_s2.sch
.subckt sw_s2 a b ctl ctlb vdd vss
*.PININFO ctl:I ctlb:I a:B b:B vdd:B vss:B
XN b ctl a vss nfet_03v3 L=0.28u W=0.36u nf=1 m=1 ad=0.1584p as=0.1584p pd=1.60u ps=1.60u
.ends

* expanding   symbol:  sw_s0.sym # of pins=6
** sym_path: /foss/designs/mixed_signal/vrlo_ref/macro/ref_analog_top/sw_s0.sym
** sch_path: /foss/designs/mixed_signal/vrlo_ref/macro/ref_analog_top/sw_s0.sch
.subckt sw_s0 a b ctl ctlb vdd vss
*.PININFO ctl:I ctlb:I a:B b:B vdd:B vss:B
XN b ctl a vss nfet_03v3 L=0.28u W=0.50u nf=1 m=1 ad=0.2200p as=0.2200p pd=1.88u ps=1.88u
XP b ctlb a vdd pfet_03v3 L=0.28u W=1.00u nf=1 m=1 ad=0.4400p as=0.4400p pd=2.88u ps=2.88u
.ends

* expanding   symbol:  sw_s1.sym # of pins=6
** sym_path: /foss/designs/mixed_signal/vrlo_ref/macro/ref_analog_top/sw_s1.sym
** sch_path: /foss/designs/mixed_signal/vrlo_ref/macro/ref_analog_top/sw_s1.sch
.subckt sw_s1 a b ctl ctlb vdd vss
*.PININFO ctl:I ctlb:I a:B b:B vdd:B vss:B
XN b ctl a vss nfet_03v3 L=0.28u W=0.50u nf=1 m=1 ad=0.2200p as=0.2200p pd=1.88u ps=1.88u
XP b ctlb a vdd pfet_03v3 L=0.28u W=1.00u nf=1 m=1 ad=0.4400p as=0.4400p pd=2.88u ps=2.88u
.ends

* expanding   symbol:  comparator.sym # of pins=8
** sym_path: /foss/designs/mixed_signal/comparator/comparator.sym
** sch_path: /foss/designs/mixed_signal/comparator/comparator.sch
.subckt comparator inp inn dout clk vdd vss nbias pbias
*.PININFO vdd:B vss:B pbias:I inp:I inn:I dout:O clk:I nbias:I
XTAIL tail pbias vdd vdd pfet_03v3 L=0.28u W=11u nf=11 ad='int((nf+1)/2) * W/nf * 0.18u' as='int((nf+2)/2) * W/nf * 0.18u' pd='2*int((nf+1)/2) * (W/nf + 0.18u)'
+ ps='2*int((nf+2)/2) * (W/nf + 0.18u)' nrd='0.18u / W' nrs='0.18u / W' sa=0 sb=0 sd=0
XINP left inp tail vdd pfet_03v3 L=0.32u W=12u nf=12 ad='int((nf+1)/2) * W/nf * 0.18u' as='int((nf+2)/2) * W/nf * 0.18u' pd='2*int((nf+1)/2) * (W/nf + 0.18u)'
+ ps='2*int((nf+2)/2) * (W/nf + 0.18u)' nrd='0.18u / W' nrs='0.18u / W' sa=0 sb=0 sd=0
XINN outa inn tail vdd pfet_03v3 L=0.32u W=12u nf=12 ad='int((nf+1)/2) * W/nf * 0.18u' as='int((nf+2)/2) * W/nf * 0.18u' pd='2*int((nf+1)/2) * (W/nf + 0.18u)'
+ ps='2*int((nf+2)/2) * (W/nf + 0.18u)' nrd='0.18u / W' nrs='0.18u / W' sa=0 sb=0 sd=0
XLOADD left left vss vss nfet_03v3 L=0.36u W=0.5u nf=1 ad='int((nf+1)/2) * W/nf * 0.18u' as='int((nf+2)/2) * W/nf * 0.18u' pd='2*int((nf+1)/2) * (W/nf + 0.18u)'
+ ps='2*int((nf+2)/2) * (W/nf + 0.18u)' nrd='0.18u / W' nrs='0.18u / W' sa=0 sb=0 sd=0
XLOADM outa left vss vss nfet_03v3 L=0.36u W=0.5u nf=1 ad='int((nf+1)/2) * W/nf * 0.18u' as='int((nf+2)/2) * W/nf * 0.18u' pd='2*int((nf+1)/2) * (W/nf + 0.18u)'
+ ps='2*int((nf+2)/2) * (W/nf + 0.18u)' nrd='0.18u / W' nrs='0.18u / W' sa=0 sb=0 sd=0
XBST bst pbias vdd vdd pfet_03v3 L=0.28u W=5u nf=5 ad='int((nf+1)/2) * W/nf * 0.18u' as='int((nf+2)/2) * W/nf * 0.18u' pd='2*int((nf+1)/2) * (W/nf + 0.18u)'
+ ps='2*int((nf+2)/2) * (W/nf + 0.18u)' nrd='0.18u / W' nrs='0.18u / W' sa=0 sb=0 sd=0
XBUF2 outb outa bst vdd pfet_03v3 L=0.36u W=1u nf=1 ad='int((nf+1)/2) * W/nf * 0.18u' as='int((nf+2)/2) * W/nf * 0.18u' pd='2*int((nf+1)/2) * (W/nf + 0.18u)'
+ ps='2*int((nf+2)/2) * (W/nf + 0.18u)' nrd='0.18u / W' nrs='0.18u / W' sa=0 sb=0 sd=0
XBUF1 outb outa vss vss nfet_03v3 L=0.36u W=0.5u nf=1 ad='int((nf+1)/2) * W/nf * 0.18u' as='int((nf+2)/2) * W/nf * 0.18u' pd='2*int((nf+1)/2) * (W/nf + 0.18u)'
+ ps='2*int((nf+2)/2) * (W/nf + 0.18u)' nrd='0.18u / W' nrs='0.18u / W' sa=0 sb=0 sd=0
XBUF4 dout outb vdd vdd pfet_03v3 L=0.36u W=1u nf=1 ad='int((nf+1)/2) * W/nf * 0.18u' as='int((nf+2)/2) * W/nf * 0.18u' pd='2*int((nf+1)/2) * (W/nf + 0.18u)'
+ ps='2*int((nf+2)/2) * (W/nf + 0.18u)' nrd='0.18u / W' nrs='0.18u / W' sa=0 sb=0 sd=0
XBUF3 dout outb vss vss nfet_03v3 L=0.36u W=0.5u nf=1 ad='int((nf+1)/2) * W/nf * 0.18u' as='int((nf+2)/2) * W/nf * 0.18u' pd='2*int((nf+1)/2) * (W/nf + 0.18u)'
+ ps='2*int((nf+2)/2) * (W/nf + 0.18u)' nrd='0.18u / W' nrs='0.18u / W' sa=0 sb=0 sd=0
.ends

* expanding   symbol:  tspc_dff.sym # of pins=5
** sym_path: /foss/designs/mixed_signal/latch_bkp/cmp_tspc/tspc_dff.sym
** sch_path: /foss/designs/mixed_signal/latch_bkp/cmp_tspc/tspc_dff.sch
.subckt tspc_dff d clk q vdd vss
*.PININFO vdd:B vss:B d:I clk:I q:O
XP3 a d vdd vdd pfet_03v3 L=0.28u W=0.84u nf=1 ad='int((nf+1)/2) * W/nf * 0.18u' as='int((nf+2)/2) * W/nf * 0.18u' pd='2*int((nf+1)/2) * (W/nf + 0.18u)'
+ ps='2*int((nf+2)/2) * (W/nf + 0.18u)' nrd='0.18u / W' nrs='0.18u / W' sa=0 sb=0 sd=0
XN2 a clk n1 vss nfet_03v3 L=0.6u W=0.42u nf=1 ad='int((nf+1)/2) * W/nf * 0.18u' as='int((nf+2)/2) * W/nf * 0.18u' pd='2*int((nf+1)/2) * (W/nf + 0.18u)'
+ ps='2*int((nf+2)/2) * (W/nf + 0.18u)' nrd='0.18u / W' nrs='0.18u / W' sa=0 sb=0 sd=0
XN1 n1 d vss vss nfet_03v3 L=0.28u W=0.42u nf=1 ad='int((nf+1)/2) * W/nf * 0.18u' as='int((nf+2)/2) * W/nf * 0.18u' pd='2*int((nf+1)/2) * (W/nf + 0.18u)'
+ ps='2*int((nf+2)/2) * (W/nf + 0.18u)' nrd='0.18u / W' nrs='0.18u / W' sa=0 sb=0 sd=0
XP6 n2 clk vdd vdd pfet_03v3 L=0.28u W=1.0u nf=1 ad='int((nf+1)/2) * W/nf * 0.18u' as='int((nf+2)/2) * W/nf * 0.18u' pd='2*int((nf+1)/2) * (W/nf + 0.18u)'
+ ps='2*int((nf+2)/2) * (W/nf + 0.18u)' nrd='0.18u / W' nrs='0.18u / W' sa=0 sb=0 sd=0
XP5 x a n2 vdd pfet_03v3 L=0.28u W=1.0u nf=1 ad='int((nf+1)/2) * W/nf * 0.18u' as='int((nf+2)/2) * W/nf * 0.18u' pd='2*int((nf+1)/2) * (W/nf + 0.18u)'
+ ps='2*int((nf+2)/2) * (W/nf + 0.18u)' nrd='0.18u / W' nrs='0.18u / W' sa=0 sb=0 sd=0
XN4 x clk vss vss nfet_03v3 L=0.28u W=1.0u nf=1 ad='int((nf+1)/2) * W/nf * 0.18u' as='int((nf+2)/2) * W/nf * 0.18u' pd='2*int((nf+1)/2) * (W/nf + 0.18u)'
+ ps='2*int((nf+2)/2) * (W/nf + 0.18u)' nrd='0.18u / W' nrs='0.18u / W' sa=0 sb=0 sd=0
XP9 n3 x vdd vdd pfet_03v3 L=0.28u W=0.42u nf=1 ad='int((nf+1)/2) * W/nf * 0.18u' as='int((nf+2)/2) * W/nf * 0.18u' pd='2*int((nf+1)/2) * (W/nf + 0.18u)'
+ ps='2*int((nf+2)/2) * (W/nf + 0.18u)' nrd='0.18u / W' nrs='0.18u / W' sa=0 sb=0 sd=0
XP8 qb clk n3 vdd pfet_03v3 L=0.28u W=0.42u nf=1 ad='int((nf+1)/2) * W/nf * 0.18u' as='int((nf+2)/2) * W/nf * 0.18u' pd='2*int((nf+1)/2) * (W/nf + 0.18u)'
+ ps='2*int((nf+2)/2) * (W/nf + 0.18u)' nrd='0.18u / W' nrs='0.18u / W' sa=0 sb=0 sd=0
XN7 qb x vss vss nfet_03v3 L=0.28u W=0.42u nf=1 ad='int((nf+1)/2) * W/nf * 0.18u' as='int((nf+2)/2) * W/nf * 0.18u' pd='2*int((nf+1)/2) * (W/nf + 0.18u)'
+ ps='2*int((nf+2)/2) * (W/nf + 0.18u)' nrd='0.18u / W' nrs='0.18u / W' sa=0 sb=0 sd=0
XP11 q qb vdd vdd pfet_03v3 L=0.28u W=2.0u nf=1 ad='int((nf+1)/2) * W/nf * 0.18u' as='int((nf+2)/2) * W/nf * 0.18u' pd='2*int((nf+1)/2) * (W/nf + 0.18u)'
+ ps='2*int((nf+2)/2) * (W/nf + 0.18u)' nrd='0.18u / W' nrs='0.18u / W' sa=0 sb=0 sd=0
XN10 q qb vss vss nfet_03v3 L=0.28u W=1.0u nf=1 ad='int((nf+1)/2) * W/nf * 0.18u' as='int((nf+2)/2) * W/nf * 0.18u' pd='2*int((nf+1)/2) * (W/nf + 0.18u)'
+ ps='2*int((nf+2)/2) * (W/nf + 0.18u)' nrd='0.18u / W' nrs='0.18u / W' sa=0 sb=0 sd=0
XP12 qb q vdd vdd pfet_03v3 L=1.0u W=0.42u nf=1 ad='int((nf+1)/2) * W/nf * 0.18u' as='int((nf+2)/2) * W/nf * 0.18u' pd='2*int((nf+1)/2) * (W/nf + 0.18u)'
+ ps='2*int((nf+2)/2) * (W/nf + 0.18u)' nrd='0.18u / W' nrs='0.18u / W' sa=0 sb=0 sd=0
XN12 qb q vss vss nfet_03v3 L=3.0u W=0.42u nf=1 ad='int((nf+1)/2) * W/nf * 0.18u' as='int((nf+2)/2) * W/nf * 0.18u' pd='2*int((nf+1)/2) * (W/nf + 0.18u)'
+ ps='2*int((nf+2)/2) * (W/nf + 0.18u)' nrd='0.18u / W' nrs='0.18u / W' sa=0 sb=0 sd=0
.ends
