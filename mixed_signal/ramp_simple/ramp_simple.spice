* ramp_simple -- the shared ramp of the 8-bit bottom-plate ADC: the ramp capacitor
* (an array of the cells' 5 um unit MIM) and its reset switch to VR_LO. The ramp
* current I = C_UNIT x V_REF x F_CLK = 0.5452 uA enters at vramp from the I/C current
* source (../ic_source; an ideal source in this block's benches), so the slope is
* the unit ratio 1/73 x V_REF x F_CLK and tracks the MIM. GENERATED by size_simple.py
* (SPEC.md, DESIGN_RECIPE.md); do not hand-edit.
*   slope 134.03 mV/us on 73 x 54.52 fF + 4 cells x 19 fF + the switch's junction
*   LSB 6.702 mV; reset level VR_LO = 0.4200 V (vrlo_ref's 7/55 tap; the pre-roll budget asks
*   0.5 V - 11.67 LSB = 0.4218 V); top 2.156 V
* Ports: vramp rst vrlo vss; rst HIGH = reset (vramp held at vrlo).
* The simulators are the authority, not these lines.
.subckt ramp_simple vramp rst vrlo vss
* ---- the ramp capacitor: 73 unit MIMs (M4-M5, 5 um square, as the cells' hold capacitor
*      and the I/C source's reference capacitor); plate c0 on vramp
XCR vramp vss cap_mim_2f0_m4m5_noshield c_width=5.000u c_length=5.000u m=73
* ---- the reset switch to VR_LO
XRST vramp rst vrlo vss nfet_03v3 L=0.28u W=0.500u nf=1 m=1
.ends ramp_simple
